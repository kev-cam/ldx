// th22_hybrid.va — TH22 C-element: IV-tables + analytical keeper.
//
// Pull-up, pull-down, and output inverter use NN/IV-table characterisation
// from transistor-level DC sweeps (auto-extracted, no hand-crafting).
// The keeper (weak-feedback latch) is a one-line analytical model:
//   I_keeper = (VDD - V(Y) - V(X)) / R_KEEP
// i.e. a weak inverter driving X toward (VDD - V(Y)) through R_KEEP.
// Hysteresis emerges from the keeper + C_X feedback loop — no state
// variable, no NN state memory, no hand-crafting needed.
//
// C_X = gate cap of inverter + keeper transistors (fixed per cell).
// C_Y = next-stage gate load (instance parameter, varies with fanout).

`include "disciplines.vams"
`include "constants.vams"

module th22_hybrid(A, B, Y, VDD, VSS);
  input  A, B, VDD, VSS;
  output Y;
  electrical A, B, Y, VDD, VSS;
  electrical X;

  // Keeper: one analytical parameter from DC sweep of MPK/MNK.
  parameter real R_KEEP = 8.0e4;   // ~80 kΩ (weak inverter drive R)

  // Gate caps: C_X from inverter+keeper gates, C_Y from next stage.
  parameter real C_X = 6.4e-15;   // MPY+MNY+MPK+MNK gate caps
  parameter real C_Y = 5.0e-15;   // external load (varies per instance)

  // Grid parameters for IV-table lookups.
  parameter real DX = 0.100000;   // V_X / V_Y grid step (13 pts over 1.2V)
  parameter real DG = 0.300000;   // V_A / V_B grid step (5 pts over 1.2V)

  // Pull-up, pull-down: I(V_X, V_A, V_B) — 13×5×5 = 325 entries each.
  // Inverter: I(V_Y, V_X) — 13×13 = 169 entries.
  // (Auto-generated from Xyce DC sweeps — see chr/characterize_th22_subnets.py)
  parameter real T_PU[0:324] = '{+6.1880e-05, +3.4152e-05, +8.3512e-06, +2.9525e-08, +2.1379e-11, +4.0600e-05, +2.7042e-05, +7.5467e-06, +2.9488e-08, +2.1379e-11, +7.8348e-06, +6.6024e-06, +4.0011e-06, +2.9228e-08, +2.1379e-11, +1.9098e-08, +1.4651e-08, +1.1210e-08, +6.8365e-09, +2.1375e-11, +3.9777e-11, +3.0143e-11, +2.3698e-11, +1.9769e-11, +1.7435e-11, +6.1220e-05, +3.3592e-05, +8.0417e-06, +2.6575e-08, +1.8040e-11, +4.0380e-05, +2.6684e-05, +7.2817e-06, +2.6545e-08, +1.8040e-11, +7.8086e-06, +6.5763e-06, +3.9178e-06, +2.6334e-08, +1.8040e-11, +1.9007e-08, +1.4587e-08, +1.1165e-08, +6.6604e-09, +1.8037e-11, +3.6846e-11, +2.7306e-11, +2.0906e-11, +1.6995e-11, +1.4571e-11, +6.0493e-05, +3.3012e-05, +7.7320e-06, +2.3919e-08, +1.5132e-11, +4.0136e-05, +2.6311e-05, +7.0159e-06, +2.3894e-08, +1.5132e-11, +7.7807e-06, +6.5493e-06, +3.8316e-06, +2.3722e-08, +1.5132e-11, +1.8916e-08, +1.4524e-08, +1.1120e-08, +6.4759e-09, +1.5129e-11, +3.3996e-11, +2.4795e-11, +1.8443e-11, +1.4553e-11, +1.2087e-11, +5.9666e-05, +3.2404e-05, +7.4214e-06, +2.1526e-08, +1.2591e-11, +3.9856e-05, +2.5916e-05, +6.7485e-06, +2.1506e-08, +1.2591e-11, +7.7503e-06, +6.5210e-06, +3.7421e-06, +2.1367e-08, +1.2591e-11, +1.8819e-08, +1.4462e-08, +1.1076e-08, +6.2829e-09, +1.2590e-11, +2.9201e-11, +2.2579e-11, +1.6287e-11, +1.2420e-11, +9.9245e-12, +5.8682e-05, +3.1757e-05, +7.1087e-06, +1.9371e-08, +1.0383e-11, +3.9515e-05, +2.5495e-05, +6.4785e-06, +1.9354e-08, +1.0383e-11, +7.7148e-06, +6.4909e-06, +3.6488e-06, +1.9241e-08, +1.0383e-11, +1.8604e-08, +1.4399e-08, +1.1032e-08, +6.0817e-09, +1.0382e-11, +2.3479e-11, +2.0614e-11, +1.4416e-11, +1.0574e-11, +8.0527e-12, +5.7428e-05, +3.1054e-05, +6.7923e-06, +1.7428e-08, +8.4797e-12, +3.9059e-05, +2.5033e-05, +6.2047e-06, +1.7415e-08, +8.4797e-12, +7.6652e-06, +6.4584e-06, +3.5512e-06, +1.7323e-08, +8.4797e-12, +1.7405e-08, +1.4336e-08, +1.0989e-08, +5.8729e-09, +8.4785e-12, +1.8415e-11, +1.8223e-11, +1.2807e-11, +8.9936e-12, +6.4477e-12, +5.5685e-05, +3.0258e-05, +6.4699e-06, +1.5678e-08, +6.8546e-12, +3.8362e-05, +2.4507e-05, +5.9248e-06, +1.5667e-08, +6.8546e-12, +7.5622e-06, +6.4219e-06, +3.4481e-06, +1.5592e-08, +6.8546e-12, +1.5700e-08, +1.4259e-08, +1.0945e-08, +5.6568e-09, +6.8536e-12, +1.3901e-11, +1.4398e-11, +1.1425e-11, +7.6567e-12, +5.0874e-12, +5.3014e-05, +2.9289e-05, +6.1376e-06, +1.4098e-08, +5.4830e-12, +3.7131e-05, +2.3857e-05, +5.6354e-06, +1.4090e-08, +5.4830e-12, +7.3234e-06, +6.3764e-06, +3.3380e-06, +1.4029e-08, +5.4830e-12, +1.4119e-08, +1.3882e-08, +1.0902e-08, +5.4341e-09, +5.4821e-12, +9.8203e-12, +1.0845e-11, +1.0140e-11, +6.5411e-12, +3.9503e-12, +4.8648e-05, +2.7948e-05, +5.7878e-06, +1.2672e-08, +4.3399e-12, +3.4807e-05, +2.2928e-05, +5.3297e-06, +1.2665e-08, +4.3399e-12, +6.9414e-06, +6.3000e-06, +3.2177e-06, +1.2616e-08, +4.3399e-12, +1.2688e-08, +1.2675e-08, +1.0856e-08, +5.2052e-09, +4.3393e-12, +6.1015e-12, +7.8230e-12, +8.0388e-12, +5.6225e-12, +3.0146e-12, +4.1577e-05, +2.5703e-05, +5.4022e-06, +1.1377e-08, +3.4005e-12, +3.0598e-05, +2.1256e-05, +4.9914e-06, +1.1371e-08, +3.4005e-12, +6.4474e-06, +6.0908e-06, +3.0794e-06, +1.1332e-08, +3.4005e-12, +1.1388e-08, +1.1388e-08, +1.0763e-08, +4.9695e-09, +3.4000e-12, +2.6303e-12, +5.1487e-12, +5.7156e-12, +4.8521e-12, +2.2589e-12, +3.1043e-05, +2.1278e-05, +4.9104e-06, +1.0177e-08, +2.6367e-12, +2.3670e-05, +1.7700e-05, +4.5562e-06, +1.0173e-08, +2.6367e-12, +5.7623e-06, +5.5341e-06, +2.8880e-06, +1.0141e-08, +2.6367e-12, +1.0183e-08, +1.0186e-08, +1.0134e-08, +4.7198e-09, +2.6363e-12, -7.2795e-13, +2.7331e-12, +3.8144e-12, +3.8714e-12, +1.6601e-12, +1.6979e-05, +1.2875e-05, +3.8619e-06, +8.8314e-09, +1.9807e-12, +1.3431e-05, +1.0762e-05, +3.5972e-06, +8.8279e-09, +1.9807e-12, +4.2994e-06, +4.0754e-06, +2.3469e-06, +8.8033e-09, +1.9807e-12, +8.8324e-09, +8.8367e-09, +8.8321e-09, +4.3507e-09, +1.9804e-12, -4.1565e-12, +4.4271e-13, +2.1847e-12, +2.4762e-12, +1.1745e-12, -9.2086e-12, -4.2079e-12, -1.2421e-12, -5.8676e-14, -7.3857e-19, -8.2950e-12, -3.2474e-12, -8.3808e-13, -5.6831e-14, -3.7887e-19, -8.6054e-12, -3.1298e-12, -7.3129e-13, -5.6430e-14, -2.7395e-19, -9.2595e-12, -3.3002e-12, -7.8446e-13, -1.0961e-13, -1.0558e-17, -9.2086e-12, -3.2474e-12, -7.3129e-13, -1.0959e-13, -2.7494e-18};
  parameter real T_PD[0:324] = '{+0.0000e+00, +2.7671e-13, +1.6840e-12, +8.0997e-12, +3.1087e-11, +3.6000e-17, +2.7676e-13, +1.8222e-12, +8.2381e-12, +3.1225e-11, +6.1039e-20, +1.3869e-13, +1.6840e-12, +8.7778e-12, +3.1696e-11, +1.0180e-20, +1.3846e-13, +1.0059e-12, +8.0997e-12, +2.9381e-11, +1.6252e-20, +1.3848e-13, +1.0750e-12, +9.8057e-12, +3.1087e-11, -5.0913e-14, +8.0837e-14, +8.9584e-13, +4.8716e-12, +2.0260e-11, -5.5394e-14, -2.5783e-11, -5.3116e-11, -4.9167e-11, -3.3778e-11, -5.5437e-14, -5.4077e-11, -1.0654e-07, -2.1759e-07, -2.1884e-07, -5.5437e-14, -5.4093e-11, -2.1160e-07, -6.4369e-06, -1.0065e-05, -5.5437e-14, -5.4093e-11, -2.1600e-07, -9.1456e-06, -1.9328e-05, -1.5290e-13, -6.5779e-14, +3.6468e-13, +2.7555e-12, +1.2816e-11, -1.5899e-13, -2.9145e-11, -6.7161e-11, -6.5428e-11, -5.5368e-11, -1.5904e-13, -6.8317e-11, -1.2106e-07, -2.6925e-07, -2.7393e-07, -1.5904e-13, -6.8342e-11, -2.6327e-07, -8.8039e-06, -1.5244e-05, -1.5904e-13, -6.8343e-11, -2.6970e-07, -1.2623e-05, -3.3411e-05, -3.4039e-13, -1.1627e-13, -7.0174e-14, +1.3301e-12, +7.7430e-12, -3.4818e-13, -3.1630e-11, -7.4618e-11, -8.0869e-11, -7.4461e-11, -3.4824e-13, -8.2514e-11, -1.3168e-07, -2.9919e-07, -3.2616e-07, -3.4824e-13, -8.2550e-11, -3.1201e-07, -9.5546e-06, -1.7518e-05, -3.4824e-13, -8.2551e-11, -3.2076e-07, -1.3949e-05, -4.2148e-05, -6.2891e-13, -1.6575e-13, -4.3253e-13, +3.1220e-13, +4.2787e-12, -6.3850e-13, -3.3714e-11, -7.6125e-11, -9.5926e-11, -9.2076e-11, -6.3857e-13, -9.6942e-11, -1.4061e-07, -3.0594e-07, -3.7734e-07, -6.3857e-13, -9.6992e-11, -3.6048e-07, -9.9752e-06, -1.8473e-05, -6.3857e-13, -9.6993e-11, -3.7184e-07, -1.4790e-05, -4.6895e-05, -1.0473e-12, -2.7306e-13, -5.5727e-13, -5.3419e-13, +1.8443e-12, -1.0588e-12, -3.5505e-11, -7.7092e-11, -1.0839e-10, -1.0849e-10, -1.0588e-12, -1.1132e-10, -1.4804e-07, -3.0971e-07, -4.2074e-07, -1.0588e-12, -1.1139e-10, -4.0782e-07, -1.0316e-05, -1.8848e-05, -1.0588e-12, -1.1139e-10, -4.2203e-07, -1.5500e-05, -4.9532e-05, -1.6511e-12, -4.6539e-13, -6.1054e-13, -1.3320e-12, +9.7760e-15, -1.6644e-12, -3.7097e-11, -7.7921e-11, -1.1223e-10, -1.2392e-10, -1.6645e-12, -1.2552e-10, -1.5422e-07, -3.1303e-07, -4.3844e-07, -1.6645e-12, -1.2561e-10, -4.5357e-07, -1.0617e-05, -1.9030e-05, -1.6645e-12, -1.2561e-10, -4.7084e-07, -1.6145e-05, -5.1256e-05, -2.5114e-12, -7.5824e-13, -6.7409e-13, -1.7389e-12, -1.5763e-12, -2.5266e-12, -3.8566e-11, -7.8654e-11, -1.1347e-10, -1.3826e-10, -2.5267e-12, -1.3950e-10, -1.5941e-07, -3.1597e-07, -4.4328e-07, -2.5267e-12, -1.3960e-10, -4.9762e-07, -1.0888e-05, -1.9156e-05, -2.5267e-12, -1.3960e-10, -5.1808e-07, -1.6741e-05, -5.2579e-05, -3.7143e-12, -1.1806e-12, -7.9399e-13, -1.8559e-12, -3.1815e-12, -3.7313e-12, -3.9989e-11, -7.9351e-11, -1.1448e-10, -1.4743e-10, -3.7314e-12, -1.5325e-10, -1.6382e-07, -3.1855e-07, -4.4706e-07, -3.7314e-12, -1.5337e-10, -5.3996e-07, -1.1133e-05, -1.9261e-05, -3.7314e-12, -1.5338e-10, -5.6376e-07, -1.7296e-05, -5.3695e-05, -5.3612e-12, -1.7881e-12, -9.9743e-13, -1.9421e-12, -4.4557e-12, -5.3801e-12, -4.1459e-11, -8.0057e-11, -1.1534e-10, -1.4951e-10, -5.3802e-12, -1.6685e-10, -1.6759e-07, -3.2081e-07, -4.5044e-07, -5.3802e-12, -1.6699e-10, -5.8067e-07, -1.1356e-05, -1.9353e-05, -5.3802e-12, -1.6700e-10, -6.0790e-07, -1.7815e-05, -5.4679e-05, -7.5703e-12, -2.6521e-12, -1.3003e-12, -2.0356e-12, -4.7970e-12, -7.5911e-12, -4.3074e-11, -8.0803e-11, -1.1610e-10, -1.5070e-10, -7.5912e-12, -1.8038e-10, -1.7087e-07, -3.2282e-07, -4.5343e-07, -7.5912e-12, -1.8055e-10, -6.1985e-07, -1.1560e-05, -1.9434e-05, -7.5912e-12, -1.8055e-10, -6.5059e-07, -1.8301e-05, -5.5566e-05, -1.0477e-11, -3.8586e-12, -1.7319e-12, -2.1819e-12, -4.9835e-12, -1.0499e-11, -4.4942e-11, -8.1628e-11, -1.1682e-10, -1.5170e-10, -1.0499e-11, -1.9395e-10, -1.7374e-07, -3.2460e-07, -4.5607e-07, -1.0499e-11, -1.9414e-10, -6.5760e-07, -1.1748e-05, -1.9508e-05, -1.0499e-11, -1.9414e-10, -6.9194e-07, -1.8758e-05, -5.6376e-05, -1.4234e-11, -5.5095e-12, -2.3482e-12, -2.4088e-12, -5.1392e-12, -1.4258e-11, -4.7180e-11, -8.2597e-11, -1.1754e-10, -1.5255e-10, -1.4258e-11, -2.0767e-10, -1.7628e-07, -3.2619e-07, -4.5839e-07, -1.4258e-11, -2.0788e-10, -6.9403e-07, -1.1921e-05, -1.9575e-05, -1.4258e-11, -2.0789e-10, -7.3202e-07, -1.9191e-05, -5.7122e-05};
  parameter real T_INV[0:168] = '{+1.1393e-04, +9.3984e-05, +7.4376e-05, +5.5506e-05, +3.7986e-05, +2.2719e-05, +1.0869e-05, +3.4536e-06, +4.8504e-07, +2.9612e-08, +1.6547e-09, +1.1836e-10, +3.6922e-11, +1.1216e-04, +9.2478e-05, +7.3091e-05, +5.4414e-05, +3.7081e-05, +2.2007e-05, +1.0190e-05, +1.6403e-06, -5.2000e-06, -1.2553e-05, -2.1205e-05, -3.0064e-05, -3.8216e-05, +1.1020e-04, +9.0849e-05, +7.1729e-05, +5.3278e-05, +3.6155e-05, +2.1298e-05, +9.6787e-06, +1.0853e-06, -6.7527e-06, -1.7362e-05, -3.1984e-05, -4.8661e-05, -6.5178e-05, +1.0800e-04, +8.9054e-05, +7.0264e-05, +5.2083e-05, +3.5198e-05, +2.0578e-05, +9.1708e-06, +6.3025e-07, -7.5601e-06, -1.9506e-05, -3.7310e-05, -5.9353e-05, -8.2811e-05, +1.0543e-04, +8.7019e-05, +6.8653e-05, +5.0807e-05, +3.4202e-05, +1.9842e-05, +8.6625e-06, +1.9560e-07, -8.2436e-06, -2.0993e-05, -4.0592e-05, -6.6030e-05, -9.4572e-05, +1.0233e-04, +8.4628e-05, +6.6824e-05, +4.9411e-05, +3.3148e-05, +1.9086e-05, +8.1528e-06, -2.2369e-07, -8.8798e-06, -2.2284e-05, -4.3136e-05, -7.0864e-05, -1.0306e-04, +9.8406e-05, +8.1675e-05, +6.4650e-05, +4.7828e-05, +3.2008e-05, +1.8296e-05, +7.6388e-06, -6.2843e-07, -9.4811e-06, -2.3480e-05, -4.5359e-05, -7.4813e-05, -1.0975e-04, +9.3165e-05, +7.7796e-05, +6.1891e-05, +4.5926e-05, +3.0722e-05, +1.7455e-05, +7.1157e-06, -1.0198e-06, -1.0052e-05, -2.4606e-05, -4.7401e-05, -7.8280e-05, -1.1539e-04, +8.5759e-05, +7.2316e-05, +5.8071e-05, +4.3422e-05, +2.9161e-05, +1.6520e-05, +6.5735e-06, -1.3999e-06, -1.0594e-05, -2.5674e-05, -4.9311e-05, -8.1438e-05, -1.2036e-04, +7.4762e-05, +6.3990e-05, +5.2214e-05, +3.9668e-05, +2.6991e-05, +1.5373e-05, +5.9877e-06, -1.7723e-06, -1.1111e-05, -2.6689e-05, -5.1115e-05, -8.4372e-05, -1.2488e-04, +5.8026e-05, +5.0700e-05, +4.2405e-05, +3.3154e-05, +2.3270e-05, +1.3619e-05, +5.2693e-06, -2.1474e-06, -1.1606e-05, -2.7658e-05, -5.2827e-05, -8.7127e-05, -1.2906e-04, +3.3194e-05, +2.9699e-05, +2.5632e-05, +2.0900e-05, +1.5514e-05, +9.7417e-06, +3.9023e-06, -2.5942e-06, -1.2085e-05, -2.8584e-05, -5.4458e-05, -8.9732e-05, -1.3296e-04, -1.8862e-11, -1.4524e-11, -2.1734e-11, -2.0952e-10, -3.5545e-09, -6.1441e-08, -7.6227e-07, -4.0367e-06, -1.2667e-05, -2.9479e-05, -5.6016e-05, -9.2207e-05, -1.3663e-04};

  // Interpolation locals
  real inv_c0, inv_c1, inv_fg, inv_fo, inv_v00, inv_v01, inv_v10, inv_v11, pd_c0, pd_c00, pd_c01, pd_c1, pd_c10, pd_c11, pd_fa, pd_fb, pd_fx, pd_v000, pd_v001, pd_v010, pd_v011, pd_v100, pd_v101, pd_v110, pd_v111, pu_c0, pu_c00, pu_c01, pu_c1, pu_c10, pu_c11, pu_fa, pu_fb, pu_fx, pu_v000, pu_v001, pu_v010, pu_v011, pu_v100, pu_v101, pu_v110, pu_v111;
  integer inv_ig, inv_io, pd_ia, pd_ib, pd_ix, pu_ia, pu_ib, pu_ix;

  real i_pu, i_pd, i_inv;

  analog begin
    // ---- Pull-up: NN/IV-table I(V_X, V_A, V_B) ----
    pu_fx = (V(X, VSS)) / 0.100000;
    if (pu_fx < 0.0) pu_fx = 0.0; if (pu_fx > 12) pu_fx = 12;
    pu_fa = (V(A, VSS)) / 0.300000;
    if (pu_fa < 0.0) pu_fa = 0.0; if (pu_fa > 4) pu_fa = 4;
    pu_fb = (V(B, VSS)) / 0.300000;
    if (pu_fb < 0.0) pu_fb = 0.0; if (pu_fb > 4) pu_fb = 4;
    pu_ix = floor(pu_fx); if (pu_ix > 11) pu_ix = 11;
    pu_ia = floor(pu_fa); if (pu_ia > 3) pu_ia = 3;
    pu_ib = floor(pu_fb); if (pu_ib > 3) pu_ib = 3;
    pu_fx = pu_fx - pu_ix; pu_fa = pu_fa - pu_ia; pu_fb = pu_fb - pu_ib;
    pu_v000 = T_PU[(pu_ix)*25+(pu_ia)*5+(pu_ib)];
    pu_v100 = T_PU[(pu_ix+1)*25+(pu_ia)*5+(pu_ib)];
    pu_v010 = T_PU[(pu_ix)*25+(pu_ia+1)*5+(pu_ib)];
    pu_v001 = T_PU[(pu_ix)*25+(pu_ia)*5+(pu_ib+1)];
    pu_v110 = T_PU[(pu_ix+1)*25+(pu_ia+1)*5+(pu_ib)];
    pu_v101 = T_PU[(pu_ix+1)*25+(pu_ia)*5+(pu_ib+1)];
    pu_v011 = T_PU[(pu_ix)*25+(pu_ia+1)*5+(pu_ib+1)];
    pu_v111 = T_PU[(pu_ix+1)*25+(pu_ia+1)*5+(pu_ib+1)];
    pu_c00 = pu_v000*(1-pu_fx)+pu_v100*pu_fx;
    pu_c10 = pu_v010*(1-pu_fx)+pu_v110*pu_fx;
    pu_c01 = pu_v001*(1-pu_fx)+pu_v101*pu_fx;
    pu_c11 = pu_v011*(1-pu_fx)+pu_v111*pu_fx;
    pu_c0 = pu_c00*(1-pu_fa)+pu_c10*pu_fa;
    pu_c1 = pu_c01*(1-pu_fa)+pu_c11*pu_fa;
    i_pu = pu_c0*(1-pu_fb)+pu_c1*pu_fb;

    // ---- Pull-down: NN/IV-table I(V_X, V_A, V_B) ----
    pd_fx = (V(X, VSS)) / 0.100000;
    if (pd_fx < 0.0) pd_fx = 0.0; if (pd_fx > 12) pd_fx = 12;
    pd_fa = (V(A, VSS)) / 0.300000;
    if (pd_fa < 0.0) pd_fa = 0.0; if (pd_fa > 4) pd_fa = 4;
    pd_fb = (V(B, VSS)) / 0.300000;
    if (pd_fb < 0.0) pd_fb = 0.0; if (pd_fb > 4) pd_fb = 4;
    pd_ix = floor(pd_fx); if (pd_ix > 11) pd_ix = 11;
    pd_ia = floor(pd_fa); if (pd_ia > 3) pd_ia = 3;
    pd_ib = floor(pd_fb); if (pd_ib > 3) pd_ib = 3;
    pd_fx = pd_fx - pd_ix; pd_fa = pd_fa - pd_ia; pd_fb = pd_fb - pd_ib;
    pd_v000 = T_PD[(pd_ix)*25+(pd_ia)*5+(pd_ib)];
    pd_v100 = T_PD[(pd_ix+1)*25+(pd_ia)*5+(pd_ib)];
    pd_v010 = T_PD[(pd_ix)*25+(pd_ia+1)*5+(pd_ib)];
    pd_v001 = T_PD[(pd_ix)*25+(pd_ia)*5+(pd_ib+1)];
    pd_v110 = T_PD[(pd_ix+1)*25+(pd_ia+1)*5+(pd_ib)];
    pd_v101 = T_PD[(pd_ix+1)*25+(pd_ia)*5+(pd_ib+1)];
    pd_v011 = T_PD[(pd_ix)*25+(pd_ia+1)*5+(pd_ib+1)];
    pd_v111 = T_PD[(pd_ix+1)*25+(pd_ia+1)*5+(pd_ib+1)];
    pd_c00 = pd_v000*(1-pd_fx)+pd_v100*pd_fx;
    pd_c10 = pd_v010*(1-pd_fx)+pd_v110*pd_fx;
    pd_c01 = pd_v001*(1-pd_fx)+pd_v101*pd_fx;
    pd_c11 = pd_v011*(1-pd_fx)+pd_v111*pd_fx;
    pd_c0 = pd_c00*(1-pd_fa)+pd_c10*pd_fa;
    pd_c1 = pd_c01*(1-pd_fa)+pd_c11*pd_fa;
    i_pd = pd_c0*(1-pd_fb)+pd_c1*pd_fb;

    // ---- Output inverter: NN/IV-table I(V_Y, V_X) ----
    inv_fo = (V(Y, VSS)) / 0.100000;
    if (inv_fo < 0.0) inv_fo = 0.0; if (inv_fo > 12) inv_fo = 12;
    inv_fg = (V(X, VSS)) / 0.100000;
    if (inv_fg < 0.0) inv_fg = 0.0; if (inv_fg > 12) inv_fg = 12;
    inv_io = floor(inv_fo); if (inv_io > 11) inv_io = 11;
    inv_ig = floor(inv_fg); if (inv_ig > 11) inv_ig = 11;
    inv_fo = inv_fo - inv_io; inv_fg = inv_fg - inv_ig;
    inv_v00 = T_INV[(inv_io)*13+(inv_ig)];
    inv_v10 = T_INV[(inv_io+1)*13+(inv_ig)];
    inv_v01 = T_INV[(inv_io)*13+(inv_ig+1)];
    inv_v11 = T_INV[(inv_io+1)*13+(inv_ig+1)];
    inv_c0 = inv_v00*(1-inv_fo)+inv_v10*inv_fo;
    inv_c1 = inv_v01*(1-inv_fo)+inv_v11*inv_fo;
    i_inv = inv_c0*(1-inv_fg)+inv_c1*inv_fg;

    // ---- Keeper: analytical weak inverter, ONE LINE ----
    // Drives X toward (VDD - V(Y)) through R_KEEP. At hold states
    // (X already at target), current is zero — hysteresis is maintained
    // by charge on C_X. During transitions, provides a weak restoring force.

    // ---- KCL at X: pull-up + pull-down + keeper + cap ----
    I(X, VSS) <+ -(i_pu + i_pd);
    I(X, VSS) <+ -(V(VDD, VSS) - V(Y, VSS) - V(X, VSS)) / R_KEEP;
    I(X, VSS) <+ C_X * ddt(V(X, VSS));

    // ---- KCL at Y: inverter + cap ----
    I(Y, VSS) <+ -i_inv;
    I(Y, VSS) <+ C_Y * ddt(V(Y, VSS));
  end
endmodule
