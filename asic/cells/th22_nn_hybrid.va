// th22_nn_hybrid.va — NN currents + analytical keeper.
// Generated by extract_nn_hybrid.py. Mirrors th22_hybrid.va topology;
// two small MLPs replace the IV-table lookups.

`include "disciplines.vams"
`include "constants.vams"

module th22_nn_hybrid(A, B, Y, VDD, VSS);
  input  A, B, VDD, VSS;
  output Y;
  electrical A, B, Y, VDD, VSS;
  electrical X;

  parameter real R_KEEP = 8.0e4;
  parameter real C_X    = 6.4e-15;
  parameter real C_Y    = 5.0e-15;

  parameter real drive_W1[0:127] = '{-5.150484e-02, +1.425521e+00, -1.299678e+00, -2.867984e-01, -1.364374e-01, -7.890024e-01, +1.697127e+00, +5.489524e-01, -1.476061e-01, -1.859987e-01, -1.022655e-01, +4.956707e-01, +5.627388e-01, -2.788731e-01, +5.899247e-01, +5.285238e-01, -4.029403e-01, +3.096011e-01, -5.709352e-01, -3.867547e-01, -5.529532e-01, -8.482134e-01, -4.627605e-01, +1.537137e+00, +1.860966e-01, -1.844873e+00, -7.548403e-01, -2.938989e-01, -5.864221e-01, +6.499193e-01, -4.597411e-01, +4.977661e-01, -2.804410e-01, -1.404099e+00, +1.747116e+00, -2.659276e-01, -1.058363e-02, +1.903338e+00, -4.772807e-01, +2.366289e-02, +3.359117e-02, +2.097059e-02, -2.159632e+00, +1.919583e-02, +2.985125e+00, -4.605877e-01, +4.416472e-01, +8.685305e-01, -1.882801e-01, +7.993476e-01, +2.202456e-01, -3.588580e-01, +1.586703e-02, +1.138852e+00, -2.178907e+00, -1.861244e-02, +3.762794e-01, +1.436407e-01, +4.341740e-01, +8.753626e-02, +1.206723e+00, +4.167565e-02, +2.699763e-02, +4.460426e-02, -1.785336e-01, -1.381946e+00, +1.125476e+00, +3.379450e-01, -3.967081e-01, -8.610095e-01, +1.791988e+00, -3.252428e+00, -1.391381e-01, -2.993686e-02, +1.475901e+00, -1.693863e+00, -7.249609e-01, -1.120245e-01, -1.941198e+00, +2.542674e-01, -1.301074e-01, +2.404422e+00, +1.092078e-01, -3.662846e-02, -5.653879e-02, -1.747148e+00, -7.002371e-01, -6.355834e-01, +1.380550e-01, +1.028750e+00, -8.286518e-03, +1.736051e+00, -6.394437e-01, +8.347138e-02, +2.893488e-03, +2.600515e-01, -3.816916e-01, +4.779264e-01, -1.249347e+00, -7.041677e-01, -9.171308e-02, -7.455603e-01, -2.465589e+00, +2.132987e+00, -2.492977e-01, -1.863163e-01, +1.930257e+00, -1.873495e+00, -1.747577e+00, -6.010258e-02, +1.916168e+00, +8.150550e-01, -3.081375e-01, -1.169486e+00, +6.550370e-03, -3.159251e-01, +7.484894e-02, +5.804454e-01, +1.642717e+00, +1.149419e+00, +2.435482e-01, -7.320975e-01, -3.436476e-02, -1.639885e+00, -5.213573e-01, +1.135070e+00, -6.439024e-01, +1.072188e+00};
  parameter real drive_b1[0:31] = '{-1.432714e-02, +3.476863e-01, -6.904058e-02, -3.085888e-02, +3.175383e-04, -8.385629e-01, -2.872165e-01, +8.997867e-01, -1.570932e-04, -6.843509e-04, -3.892598e+00, +3.373981e+00, +1.240659e+00, -1.303960e-03, -4.452320e-01, -3.560996e-01, -1.539408e-03, -1.251718e+00, +3.286594e-03, -2.726969e-04, +2.542689e-03, +5.039382e-01, -1.151720e+00, -2.035151e+00, -1.156972e-01, +1.592085e+00, -9.823825e-04, -3.090312e-01, -4.420971e-01, -7.355078e-01, +4.387922e-03, -4.860355e-01};
  parameter real drive_W2[0:31] = '{-5.164772e-06, +2.085853e-05, -1.954305e-05, +4.445394e-06, +3.708040e-07, -2.328207e-05, +2.327790e-05, +2.772959e-05, -1.887142e-07, -8.061472e-07, +4.651488e-05, -3.562954e-05, +2.438218e-05, -1.524230e-06, -1.715969e-05, -1.025690e-05, -1.808073e-06, -1.783695e-05, +3.738203e-06, -3.453382e-07, +2.888320e-06, -2.096992e-05, -2.967197e-05, -1.814075e-05, -3.778286e-06, +2.328448e-05, -1.208320e-06, -2.134779e-05, -1.555621e-05, -9.951732e-06, +5.029988e-06, -8.462220e-06};
  parameter real drive_b2 = +8.654343e-06;

  parameter real inv_W1[0:71] = '{-8.778007e-01, +1.635339e+00, -3.172947e-02, -2.170153e-01, -1.332729e-01, -1.635673e-01, +5.620438e-01, +3.390389e-01, -5.546575e-02, -5.523415e-01, +4.224403e-01, -5.933371e-02, +3.494138e+00, +2.738034e+00, -1.141679e-01, -2.037916e+00, +2.388828e-01, +3.069412e+00, -5.411962e-02, -1.371099e+00, -4.097833e-01, -4.532389e-01, +5.737251e-01, -2.226499e-01, -1.848814e+00, -4.946500e-01, -3.165898e+00, -3.610732e-01, -5.051233e+00, -5.023092e-04, +7.464225e-01, -6.711303e-01, +2.430459e+00, +1.100961e-01, +1.333201e+00, -9.568620e-02, -2.181730e+00, +8.652317e-01, -6.079684e-02, -1.595075e+00, +2.222695e-01, +4.610311e-01, +2.610387e+00, -1.938830e+00, -9.052803e-01, -2.545423e-01, -3.793718e+00, +1.371053e-02, +1.692110e+00, -1.296725e+00, +3.292356e+00, +1.353084e-01, +1.025765e-01, +1.041682e-01, +1.794586e+00, -4.692459e-01, +1.713149e+00, +1.711643e-01, -1.696464e+00, +4.668343e-02, -3.678859e-01, +3.971284e+00, -1.294158e-01, +3.282464e+00, +4.435052e-01, -2.492342e+00, -4.356028e+00, +3.822328e+00, +3.286555e-01, -1.621048e-01, +3.071321e+00, +1.486094e-01};
  parameter real inv_b1[0:23] = '{-1.514321e-01, -2.061822e-01, +3.587456e+00, -6.247690e-02, +4.966835e+00, -5.529523e-03, +1.580865e-02, -3.601672e-01, -4.403677e+00, +1.424865e-03, +2.887181e-01, -3.150398e-02, -2.943261e+00, -1.444173e+00, -3.336827e-04, -1.638536e+00, -8.307825e-02, -1.347855e-01, -2.839495e+00, -2.077368e+00, -4.709151e-02, +8.394929e-04, +2.015963e+00, -2.025159e-02};
  parameter real inv_W2[0:23] = '{-2.519569e-05, +1.875583e-05, +5.382032e-05, +5.250268e-06, -6.765807e-05, +2.609183e-06, -1.864093e-05, +8.663136e-06, -5.112435e-05, +3.681977e-06, -1.991191e-05, +1.578965e-06, +4.979539e-05, -4.653123e-05, -8.704749e-07, -4.459002e-05, -4.723291e-06, +3.786567e-05, +5.785575e-05, -4.862810e-05, -9.976842e-06, +2.165918e-06, +4.758972e-05, +1.150505e-06};
  parameter real inv_b2 = +3.858543e-06;

  real z_drive[0:31], h_drive[0:31], y_drive;
  real z_inv  [0:31], h_inv  [0:31], y_inv;
  real i_drive, i_inv;

  analog begin
    // NN forward pass: drive currents (pull-up + pull-down combined)
    z_drive[0] = drive_W1[0] * V(X, VSS) + drive_W1[32] * V(A, VSS) + drive_W1[64] * V(B, VSS) + drive_b1[0];
    if (z_drive[0] > 0.0) h_drive[0] = z_drive[0]; else h_drive[0] = 0.01 * z_drive[0];
    z_drive[1] = drive_W1[1] * V(X, VSS) + drive_W1[33] * V(A, VSS) + drive_W1[65] * V(B, VSS) + drive_b1[1];
    if (z_drive[1] > 0.0) h_drive[1] = z_drive[1]; else h_drive[1] = 0.01 * z_drive[1];
    z_drive[2] = drive_W1[2] * V(X, VSS) + drive_W1[34] * V(A, VSS) + drive_W1[66] * V(B, VSS) + drive_b1[2];
    if (z_drive[2] > 0.0) h_drive[2] = z_drive[2]; else h_drive[2] = 0.01 * z_drive[2];
    z_drive[3] = drive_W1[3] * V(X, VSS) + drive_W1[35] * V(A, VSS) + drive_W1[67] * V(B, VSS) + drive_b1[3];
    if (z_drive[3] > 0.0) h_drive[3] = z_drive[3]; else h_drive[3] = 0.01 * z_drive[3];
    z_drive[4] = drive_W1[4] * V(X, VSS) + drive_W1[36] * V(A, VSS) + drive_W1[68] * V(B, VSS) + drive_b1[4];
    if (z_drive[4] > 0.0) h_drive[4] = z_drive[4]; else h_drive[4] = 0.01 * z_drive[4];
    z_drive[5] = drive_W1[5] * V(X, VSS) + drive_W1[37] * V(A, VSS) + drive_W1[69] * V(B, VSS) + drive_b1[5];
    if (z_drive[5] > 0.0) h_drive[5] = z_drive[5]; else h_drive[5] = 0.01 * z_drive[5];
    z_drive[6] = drive_W1[6] * V(X, VSS) + drive_W1[38] * V(A, VSS) + drive_W1[70] * V(B, VSS) + drive_b1[6];
    if (z_drive[6] > 0.0) h_drive[6] = z_drive[6]; else h_drive[6] = 0.01 * z_drive[6];
    z_drive[7] = drive_W1[7] * V(X, VSS) + drive_W1[39] * V(A, VSS) + drive_W1[71] * V(B, VSS) + drive_b1[7];
    if (z_drive[7] > 0.0) h_drive[7] = z_drive[7]; else h_drive[7] = 0.01 * z_drive[7];
    z_drive[8] = drive_W1[8] * V(X, VSS) + drive_W1[40] * V(A, VSS) + drive_W1[72] * V(B, VSS) + drive_b1[8];
    if (z_drive[8] > 0.0) h_drive[8] = z_drive[8]; else h_drive[8] = 0.01 * z_drive[8];
    z_drive[9] = drive_W1[9] * V(X, VSS) + drive_W1[41] * V(A, VSS) + drive_W1[73] * V(B, VSS) + drive_b1[9];
    if (z_drive[9] > 0.0) h_drive[9] = z_drive[9]; else h_drive[9] = 0.01 * z_drive[9];
    z_drive[10] = drive_W1[10] * V(X, VSS) + drive_W1[42] * V(A, VSS) + drive_W1[74] * V(B, VSS) + drive_b1[10];
    if (z_drive[10] > 0.0) h_drive[10] = z_drive[10]; else h_drive[10] = 0.01 * z_drive[10];
    z_drive[11] = drive_W1[11] * V(X, VSS) + drive_W1[43] * V(A, VSS) + drive_W1[75] * V(B, VSS) + drive_b1[11];
    if (z_drive[11] > 0.0) h_drive[11] = z_drive[11]; else h_drive[11] = 0.01 * z_drive[11];
    z_drive[12] = drive_W1[12] * V(X, VSS) + drive_W1[44] * V(A, VSS) + drive_W1[76] * V(B, VSS) + drive_b1[12];
    if (z_drive[12] > 0.0) h_drive[12] = z_drive[12]; else h_drive[12] = 0.01 * z_drive[12];
    z_drive[13] = drive_W1[13] * V(X, VSS) + drive_W1[45] * V(A, VSS) + drive_W1[77] * V(B, VSS) + drive_b1[13];
    if (z_drive[13] > 0.0) h_drive[13] = z_drive[13]; else h_drive[13] = 0.01 * z_drive[13];
    z_drive[14] = drive_W1[14] * V(X, VSS) + drive_W1[46] * V(A, VSS) + drive_W1[78] * V(B, VSS) + drive_b1[14];
    if (z_drive[14] > 0.0) h_drive[14] = z_drive[14]; else h_drive[14] = 0.01 * z_drive[14];
    z_drive[15] = drive_W1[15] * V(X, VSS) + drive_W1[47] * V(A, VSS) + drive_W1[79] * V(B, VSS) + drive_b1[15];
    if (z_drive[15] > 0.0) h_drive[15] = z_drive[15]; else h_drive[15] = 0.01 * z_drive[15];
    z_drive[16] = drive_W1[16] * V(X, VSS) + drive_W1[48] * V(A, VSS) + drive_W1[80] * V(B, VSS) + drive_b1[16];
    if (z_drive[16] > 0.0) h_drive[16] = z_drive[16]; else h_drive[16] = 0.01 * z_drive[16];
    z_drive[17] = drive_W1[17] * V(X, VSS) + drive_W1[49] * V(A, VSS) + drive_W1[81] * V(B, VSS) + drive_b1[17];
    if (z_drive[17] > 0.0) h_drive[17] = z_drive[17]; else h_drive[17] = 0.01 * z_drive[17];
    z_drive[18] = drive_W1[18] * V(X, VSS) + drive_W1[50] * V(A, VSS) + drive_W1[82] * V(B, VSS) + drive_b1[18];
    if (z_drive[18] > 0.0) h_drive[18] = z_drive[18]; else h_drive[18] = 0.01 * z_drive[18];
    z_drive[19] = drive_W1[19] * V(X, VSS) + drive_W1[51] * V(A, VSS) + drive_W1[83] * V(B, VSS) + drive_b1[19];
    if (z_drive[19] > 0.0) h_drive[19] = z_drive[19]; else h_drive[19] = 0.01 * z_drive[19];
    z_drive[20] = drive_W1[20] * V(X, VSS) + drive_W1[52] * V(A, VSS) + drive_W1[84] * V(B, VSS) + drive_b1[20];
    if (z_drive[20] > 0.0) h_drive[20] = z_drive[20]; else h_drive[20] = 0.01 * z_drive[20];
    z_drive[21] = drive_W1[21] * V(X, VSS) + drive_W1[53] * V(A, VSS) + drive_W1[85] * V(B, VSS) + drive_b1[21];
    if (z_drive[21] > 0.0) h_drive[21] = z_drive[21]; else h_drive[21] = 0.01 * z_drive[21];
    z_drive[22] = drive_W1[22] * V(X, VSS) + drive_W1[54] * V(A, VSS) + drive_W1[86] * V(B, VSS) + drive_b1[22];
    if (z_drive[22] > 0.0) h_drive[22] = z_drive[22]; else h_drive[22] = 0.01 * z_drive[22];
    z_drive[23] = drive_W1[23] * V(X, VSS) + drive_W1[55] * V(A, VSS) + drive_W1[87] * V(B, VSS) + drive_b1[23];
    if (z_drive[23] > 0.0) h_drive[23] = z_drive[23]; else h_drive[23] = 0.01 * z_drive[23];
    z_drive[24] = drive_W1[24] * V(X, VSS) + drive_W1[56] * V(A, VSS) + drive_W1[88] * V(B, VSS) + drive_b1[24];
    if (z_drive[24] > 0.0) h_drive[24] = z_drive[24]; else h_drive[24] = 0.01 * z_drive[24];
    z_drive[25] = drive_W1[25] * V(X, VSS) + drive_W1[57] * V(A, VSS) + drive_W1[89] * V(B, VSS) + drive_b1[25];
    if (z_drive[25] > 0.0) h_drive[25] = z_drive[25]; else h_drive[25] = 0.01 * z_drive[25];
    z_drive[26] = drive_W1[26] * V(X, VSS) + drive_W1[58] * V(A, VSS) + drive_W1[90] * V(B, VSS) + drive_b1[26];
    if (z_drive[26] > 0.0) h_drive[26] = z_drive[26]; else h_drive[26] = 0.01 * z_drive[26];
    z_drive[27] = drive_W1[27] * V(X, VSS) + drive_W1[59] * V(A, VSS) + drive_W1[91] * V(B, VSS) + drive_b1[27];
    if (z_drive[27] > 0.0) h_drive[27] = z_drive[27]; else h_drive[27] = 0.01 * z_drive[27];
    z_drive[28] = drive_W1[28] * V(X, VSS) + drive_W1[60] * V(A, VSS) + drive_W1[92] * V(B, VSS) + drive_b1[28];
    if (z_drive[28] > 0.0) h_drive[28] = z_drive[28]; else h_drive[28] = 0.01 * z_drive[28];
    z_drive[29] = drive_W1[29] * V(X, VSS) + drive_W1[61] * V(A, VSS) + drive_W1[93] * V(B, VSS) + drive_b1[29];
    if (z_drive[29] > 0.0) h_drive[29] = z_drive[29]; else h_drive[29] = 0.01 * z_drive[29];
    z_drive[30] = drive_W1[30] * V(X, VSS) + drive_W1[62] * V(A, VSS) + drive_W1[94] * V(B, VSS) + drive_b1[30];
    if (z_drive[30] > 0.0) h_drive[30] = z_drive[30]; else h_drive[30] = 0.01 * z_drive[30];
    z_drive[31] = drive_W1[31] * V(X, VSS) + drive_W1[63] * V(A, VSS) + drive_W1[95] * V(B, VSS) + drive_b1[31];
    if (z_drive[31] > 0.0) h_drive[31] = z_drive[31]; else h_drive[31] = 0.01 * z_drive[31];
    y_drive = drive_W2[0] * h_drive[0] + drive_W2[1] * h_drive[1] + drive_W2[2] * h_drive[2] + drive_W2[3] * h_drive[3] + drive_W2[4] * h_drive[4] + drive_W2[5] * h_drive[5] + drive_W2[6] * h_drive[6] + drive_W2[7] * h_drive[7] + drive_W2[8] * h_drive[8] + drive_W2[9] * h_drive[9] + drive_W2[10] * h_drive[10] + drive_W2[11] * h_drive[11] + drive_W2[12] * h_drive[12] + drive_W2[13] * h_drive[13] + drive_W2[14] * h_drive[14] + drive_W2[15] * h_drive[15] + drive_W2[16] * h_drive[16] + drive_W2[17] * h_drive[17] + drive_W2[18] * h_drive[18] + drive_W2[19] * h_drive[19] + drive_W2[20] * h_drive[20] + drive_W2[21] * h_drive[21] + drive_W2[22] * h_drive[22] + drive_W2[23] * h_drive[23] + drive_W2[24] * h_drive[24] + drive_W2[25] * h_drive[25] + drive_W2[26] * h_drive[26] + drive_W2[27] * h_drive[27] + drive_W2[28] * h_drive[28] + drive_W2[29] * h_drive[29] + drive_W2[30] * h_drive[30] + drive_W2[31] * h_drive[31] + drive_b2;
    i_drive = y_drive;

    // NN forward pass: inverter current
    z_inv[0] = inv_W1[0] * V(X, VSS) + inv_W1[32] * V(Y, VSS) + inv_b1[0];
    if (z_inv[0] > 0.0) h_inv[0] = z_inv[0]; else h_inv[0] = 0.01 * z_inv[0];
    z_inv[1] = inv_W1[1] * V(X, VSS) + inv_W1[33] * V(Y, VSS) + inv_b1[1];
    if (z_inv[1] > 0.0) h_inv[1] = z_inv[1]; else h_inv[1] = 0.01 * z_inv[1];
    z_inv[2] = inv_W1[2] * V(X, VSS) + inv_W1[34] * V(Y, VSS) + inv_b1[2];
    if (z_inv[2] > 0.0) h_inv[2] = z_inv[2]; else h_inv[2] = 0.01 * z_inv[2];
    z_inv[3] = inv_W1[3] * V(X, VSS) + inv_W1[35] * V(Y, VSS) + inv_b1[3];
    if (z_inv[3] > 0.0) h_inv[3] = z_inv[3]; else h_inv[3] = 0.01 * z_inv[3];
    z_inv[4] = inv_W1[4] * V(X, VSS) + inv_W1[36] * V(Y, VSS) + inv_b1[4];
    if (z_inv[4] > 0.0) h_inv[4] = z_inv[4]; else h_inv[4] = 0.01 * z_inv[4];
    z_inv[5] = inv_W1[5] * V(X, VSS) + inv_W1[37] * V(Y, VSS) + inv_b1[5];
    if (z_inv[5] > 0.0) h_inv[5] = z_inv[5]; else h_inv[5] = 0.01 * z_inv[5];
    z_inv[6] = inv_W1[6] * V(X, VSS) + inv_W1[38] * V(Y, VSS) + inv_b1[6];
    if (z_inv[6] > 0.0) h_inv[6] = z_inv[6]; else h_inv[6] = 0.01 * z_inv[6];
    z_inv[7] = inv_W1[7] * V(X, VSS) + inv_W1[39] * V(Y, VSS) + inv_b1[7];
    if (z_inv[7] > 0.0) h_inv[7] = z_inv[7]; else h_inv[7] = 0.01 * z_inv[7];
    z_inv[8] = inv_W1[8] * V(X, VSS) + inv_W1[40] * V(Y, VSS) + inv_b1[8];
    if (z_inv[8] > 0.0) h_inv[8] = z_inv[8]; else h_inv[8] = 0.01 * z_inv[8];
    z_inv[9] = inv_W1[9] * V(X, VSS) + inv_W1[41] * V(Y, VSS) + inv_b1[9];
    if (z_inv[9] > 0.0) h_inv[9] = z_inv[9]; else h_inv[9] = 0.01 * z_inv[9];
    z_inv[10] = inv_W1[10] * V(X, VSS) + inv_W1[42] * V(Y, VSS) + inv_b1[10];
    if (z_inv[10] > 0.0) h_inv[10] = z_inv[10]; else h_inv[10] = 0.01 * z_inv[10];
    z_inv[11] = inv_W1[11] * V(X, VSS) + inv_W1[43] * V(Y, VSS) + inv_b1[11];
    if (z_inv[11] > 0.0) h_inv[11] = z_inv[11]; else h_inv[11] = 0.01 * z_inv[11];
    z_inv[12] = inv_W1[12] * V(X, VSS) + inv_W1[44] * V(Y, VSS) + inv_b1[12];
    if (z_inv[12] > 0.0) h_inv[12] = z_inv[12]; else h_inv[12] = 0.01 * z_inv[12];
    z_inv[13] = inv_W1[13] * V(X, VSS) + inv_W1[45] * V(Y, VSS) + inv_b1[13];
    if (z_inv[13] > 0.0) h_inv[13] = z_inv[13]; else h_inv[13] = 0.01 * z_inv[13];
    z_inv[14] = inv_W1[14] * V(X, VSS) + inv_W1[46] * V(Y, VSS) + inv_b1[14];
    if (z_inv[14] > 0.0) h_inv[14] = z_inv[14]; else h_inv[14] = 0.01 * z_inv[14];
    z_inv[15] = inv_W1[15] * V(X, VSS) + inv_W1[47] * V(Y, VSS) + inv_b1[15];
    if (z_inv[15] > 0.0) h_inv[15] = z_inv[15]; else h_inv[15] = 0.01 * z_inv[15];
    z_inv[16] = inv_W1[16] * V(X, VSS) + inv_W1[48] * V(Y, VSS) + inv_b1[16];
    if (z_inv[16] > 0.0) h_inv[16] = z_inv[16]; else h_inv[16] = 0.01 * z_inv[16];
    z_inv[17] = inv_W1[17] * V(X, VSS) + inv_W1[49] * V(Y, VSS) + inv_b1[17];
    if (z_inv[17] > 0.0) h_inv[17] = z_inv[17]; else h_inv[17] = 0.01 * z_inv[17];
    z_inv[18] = inv_W1[18] * V(X, VSS) + inv_W1[50] * V(Y, VSS) + inv_b1[18];
    if (z_inv[18] > 0.0) h_inv[18] = z_inv[18]; else h_inv[18] = 0.01 * z_inv[18];
    z_inv[19] = inv_W1[19] * V(X, VSS) + inv_W1[51] * V(Y, VSS) + inv_b1[19];
    if (z_inv[19] > 0.0) h_inv[19] = z_inv[19]; else h_inv[19] = 0.01 * z_inv[19];
    z_inv[20] = inv_W1[20] * V(X, VSS) + inv_W1[52] * V(Y, VSS) + inv_b1[20];
    if (z_inv[20] > 0.0) h_inv[20] = z_inv[20]; else h_inv[20] = 0.01 * z_inv[20];
    z_inv[21] = inv_W1[21] * V(X, VSS) + inv_W1[53] * V(Y, VSS) + inv_b1[21];
    if (z_inv[21] > 0.0) h_inv[21] = z_inv[21]; else h_inv[21] = 0.01 * z_inv[21];
    z_inv[22] = inv_W1[22] * V(X, VSS) + inv_W1[54] * V(Y, VSS) + inv_b1[22];
    if (z_inv[22] > 0.0) h_inv[22] = z_inv[22]; else h_inv[22] = 0.01 * z_inv[22];
    z_inv[23] = inv_W1[23] * V(X, VSS) + inv_W1[55] * V(Y, VSS) + inv_b1[23];
    if (z_inv[23] > 0.0) h_inv[23] = z_inv[23]; else h_inv[23] = 0.01 * z_inv[23];
    z_inv[24] = inv_W1[24] * V(X, VSS) + inv_W1[56] * V(Y, VSS) + inv_b1[24];
    if (z_inv[24] > 0.0) h_inv[24] = z_inv[24]; else h_inv[24] = 0.01 * z_inv[24];
    z_inv[25] = inv_W1[25] * V(X, VSS) + inv_W1[57] * V(Y, VSS) + inv_b1[25];
    if (z_inv[25] > 0.0) h_inv[25] = z_inv[25]; else h_inv[25] = 0.01 * z_inv[25];
    z_inv[26] = inv_W1[26] * V(X, VSS) + inv_W1[58] * V(Y, VSS) + inv_b1[26];
    if (z_inv[26] > 0.0) h_inv[26] = z_inv[26]; else h_inv[26] = 0.01 * z_inv[26];
    z_inv[27] = inv_W1[27] * V(X, VSS) + inv_W1[59] * V(Y, VSS) + inv_b1[27];
    if (z_inv[27] > 0.0) h_inv[27] = z_inv[27]; else h_inv[27] = 0.01 * z_inv[27];
    z_inv[28] = inv_W1[28] * V(X, VSS) + inv_W1[60] * V(Y, VSS) + inv_b1[28];
    if (z_inv[28] > 0.0) h_inv[28] = z_inv[28]; else h_inv[28] = 0.01 * z_inv[28];
    z_inv[29] = inv_W1[29] * V(X, VSS) + inv_W1[61] * V(Y, VSS) + inv_b1[29];
    if (z_inv[29] > 0.0) h_inv[29] = z_inv[29]; else h_inv[29] = 0.01 * z_inv[29];
    z_inv[30] = inv_W1[30] * V(X, VSS) + inv_W1[62] * V(Y, VSS) + inv_b1[30];
    if (z_inv[30] > 0.0) h_inv[30] = z_inv[30]; else h_inv[30] = 0.01 * z_inv[30];
    z_inv[31] = inv_W1[31] * V(X, VSS) + inv_W1[63] * V(Y, VSS) + inv_b1[31];
    if (z_inv[31] > 0.0) h_inv[31] = z_inv[31]; else h_inv[31] = 0.01 * z_inv[31];
    y_inv = inv_W2[0] * h_inv[0] + inv_W2[1] * h_inv[1] + inv_W2[2] * h_inv[2] + inv_W2[3] * h_inv[3] + inv_W2[4] * h_inv[4] + inv_W2[5] * h_inv[5] + inv_W2[6] * h_inv[6] + inv_W2[7] * h_inv[7] + inv_W2[8] * h_inv[8] + inv_W2[9] * h_inv[9] + inv_W2[10] * h_inv[10] + inv_W2[11] * h_inv[11] + inv_W2[12] * h_inv[12] + inv_W2[13] * h_inv[13] + inv_W2[14] * h_inv[14] + inv_W2[15] * h_inv[15] + inv_W2[16] * h_inv[16] + inv_W2[17] * h_inv[17] + inv_W2[18] * h_inv[18] + inv_W2[19] * h_inv[19] + inv_W2[20] * h_inv[20] + inv_W2[21] * h_inv[21] + inv_W2[22] * h_inv[22] + inv_W2[23] * h_inv[23] + inv_W2[24] * h_inv[24] + inv_W2[25] * h_inv[25] + inv_W2[26] * h_inv[26] + inv_W2[27] * h_inv[27] + inv_W2[28] * h_inv[28] + inv_W2[29] * h_inv[29] + inv_W2[30] * h_inv[30] + inv_W2[31] * h_inv[31] + inv_b2;
    i_inv = y_inv;

    // KCL at X: drive + analytical keeper + cap
    I(X, VSS) <+ -(i_drive);
    I(X, VSS) <+ -(V(VDD, VSS) - V(Y, VSS) - V(X, VSS)) / R_KEEP;
    I(X, VSS) <+ C_X * ddt(V(X, VSS));

    // KCL at Y: inverter + cap
    I(Y, VSS) <+ -(i_inv);
    I(Y, VSS) <+ C_Y * ddt(V(Y, VSS));
  end
endmodule
