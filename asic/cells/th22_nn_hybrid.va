// th22_nn_hybrid.va — NN currents + analytical keeper.
// Generated by extract_nn_hybrid.py. Mirrors th22_hybrid.va topology;
// two small MLPs replace the IV-table lookups.

`include "disciplines.vams"
`include "constants.vams"

module th22_nn_hybrid(A, B, Y, VDD, VSS);
  input  A, B, VDD, VSS;
  output Y;
  electrical A, B, Y, VDD, VSS;
  electrical X;

  parameter real R_KEEP = 8.0e4;
  parameter real C_X    = 6.4e-15;
  parameter real C_Y    = 5.0e-15;

  parameter real drive_W1[0:191] = '{+1.639634e+00, +1.677757e-02, -1.506848e-01, -2.655213e-01, -5.932703e-01, -2.955780e-01, -2.090058e-01, +6.308420e-01, -1.502625e-01, -2.592152e-02, -1.366677e-01, +3.374579e-01, -7.801490e-02, -2.760340e-01, -1.318824e-01, -3.761143e-01, -4.015484e-01, -1.933428e-01, -9.034406e-02, -4.145255e-01, -5.559414e-01, -7.491905e-02, -1.160424e+00, +4.042693e-02, +1.216724e-02, -5.599557e-02, -7.568524e-01, -4.927958e-01, -1.472289e-02, +1.827004e-01, -4.624651e-01, -1.026538e+00, -1.299019e-01, -3.054584e-01, -4.207207e-03, -1.956059e-01, -6.850538e-01, +2.334475e-01, -1.856202e-01, -1.941882e-01, +1.034669e-01, -2.528943e-02, -4.751757e-02, +2.926845e-01, +7.921807e-01, -3.229848e-01, +2.718855e-01, +3.163301e-02, -3.283576e-02, +1.690732e+00, +4.308620e-01, -3.628243e-01, +5.929883e-03, +1.694778e-01, +8.501507e-02, -4.349015e-01, -1.514663e-02, -4.490089e-03, +1.315416e+00, -2.969517e-01, +1.869107e+00, -1.447103e-01, +7.026655e-01, +7.120942e-02, -1.769354e-01, -2.566416e-01, -2.707670e-01, +2.988511e-01, -3.907178e-01, -2.302758e-01, +8.485663e-02, -2.331360e+00, -1.379410e-01, -2.933767e-02, +3.804921e-01, +2.314534e+00, -9.730556e-02, -9.034450e-01, -6.871417e-02, +4.933058e-01, +1.821840e-02, -3.940300e-01, +8.605452e-01, +7.882677e-01, +6.826536e-01, -9.249432e-01, -3.970143e-01, +6.992672e-01, +9.259616e-01, +9.492328e-01, -2.080027e-01, +1.709170e-02, -6.436252e-01, +3.985577e-01, +1.252319e-01, +9.135840e-01, -1.662816e+00, +9.822818e-01, -1.106942e+00, -6.101385e-01, -6.871767e-01, -2.694753e-01, +2.806531e-01, +7.246189e-01, -2.502089e-01, -7.659906e-01, +9.495667e-01, +1.141352e+00, +5.750143e-01, -6.094477e-02, -2.726513e-01, +7.713208e-01, -3.096369e-01, -2.716874e-01, +1.579302e+00, -3.159191e-01, +7.705488e-02, -2.585461e-01, +1.556562e+00, +1.474657e+00, +1.611113e-01, -1.772843e-01, -3.609001e-02, -1.479313e+00, -3.395078e-01, +1.610382e+00, -6.394786e-01, +1.030955e+00, -1.879369e+00, +8.510166e-01, -3.824986e-01, +9.667511e-01, +2.923475e-01, -1.154117e+00, +4.021161e-01, +1.643768e+00, -6.917764e-01, -8.644637e-01, -1.462952e+00, -7.881063e-01, +5.061387e-01, -3.874584e-01, +4.386520e-01, -8.412070e-01, -1.780099e+00, -1.051541e+00, +1.141177e+00, -4.535126e-02, +8.361854e-01, +4.991480e-03, -6.791304e-01, +2.381621e-02, -1.694245e-01, +1.150024e-01, -1.079188e+00, -1.102301e+00, -1.416792e+00, -2.404303e-01, +2.748768e-01, -1.398796e+00, -3.153283e-01, +4.520291e-01, +1.665693e+00, -4.353315e-01, -6.433184e-02, -1.918986e-01, -8.135027e-01, +1.636165e+00, -1.977834e-01, +2.147738e-02, -2.266581e-01, -1.266484e+00, -1.619627e-01, -8.858244e-02, -3.342612e-01, -7.394573e-01, +8.389963e-01, -2.835965e-01, +4.398011e-01, -5.658796e-01, -1.211486e+00, +4.211039e-01, +1.038868e+00, -9.569832e-01, +6.877583e-03, +4.988381e-01, +1.660442e+00, +1.276191e+00, +3.250953e-01, -2.880892e-01, -5.506802e-01, +1.341955e+00};
  parameter real drive_b1[0:47] = '{-7.507618e-01, +3.500441e-01, -5.321286e-01, +3.770401e-04, +3.674430e-01, +4.369950e-04, +4.482601e-01, +3.399405e-02, -5.954532e-04, +1.824018e-01, -2.146092e-01, +5.604442e-02, +5.035268e-01, +7.104555e-04, +2.977414e-01, +7.189552e-01, +3.917296e-04, -1.581539e-01, -3.319625e+00, -2.814951e-02, -7.791300e-04, -1.004628e-03, +6.195848e-01, -3.325460e+00, -6.658645e-02, +1.850226e-05, -4.163554e-04, -1.114461e+00, -1.444767e-03, -2.814009e-01, -7.849681e-04, +1.730515e-01, +5.948025e-01, +4.739454e-02, +5.202492e-02, -2.408882e-01, +8.575974e-01, +6.024068e-01, -1.114553e+00, -1.007204e-01, +3.328611e-01, +9.856962e-02, -1.287699e-01, -5.928302e-01, +1.491797e-01, +2.294701e-02, -1.321169e-01, -6.928048e-01};
  parameter real drive_W2[0:47] = '{+2.869328e-05, -1.669998e-05, +1.487521e-05, +2.359107e-06, +1.173031e-05, +2.716521e-06, -8.134834e-06, +6.859942e-06, -3.758481e-06, +7.634351e-06, +1.598245e-05, +1.282516e-05, +1.894244e-05, +4.442125e-06, -6.315053e-06, -1.687612e-05, +2.427848e-06, -6.780428e-06, -3.053895e-05, +2.380515e-06, -4.919989e-06, -6.316302e-06, +1.702020e-05, +4.334732e-05, -2.654420e-06, +1.129447e-07, -2.691608e-06, -3.110356e-05, -4.955678e-07, -1.507258e-05, -4.977017e-06, +1.393436e-05, -1.954624e-05, +8.463897e-06, -8.035840e-06, -1.075198e-05, -1.714213e-05, -1.506461e-05, -1.254306e-05, -1.458816e-05, +9.000656e-06, +1.086516e-05, +2.025277e-05, -1.207702e-05, +9.001242e-06, -3.547509e-06, +4.456198e-06, -1.485417e-05};
  parameter real drive_b2 = +1.591514e-06;

  parameter real inv_W1[0:71] = '{-6.106077e-01, +2.006925e+00, +2.319403e-01, -2.176043e-01, -1.211843e-01, -1.634098e-01, +3.120047e-01, +1.253538e-01, -1.890769e-01, -5.523892e-01, +1.191870e+00, -5.857648e-02, +3.336816e+00, +2.185343e+00, -1.141574e-01, -1.749118e+00, +1.737840e-01, +2.455698e+00, -8.852812e-02, -1.319068e+00, -2.949918e-01, -4.532682e-01, +4.984024e-01, -2.227939e-01, -1.602921e+00, -6.017621e-01, -3.271090e+00, -3.579543e-01, -4.526549e+00, +1.561262e-03, -3.641683e-02, -3.179783e-01, +3.616711e+00, +1.121593e-01, +1.386663e+00, -9.509712e-02, -2.226615e+00, +6.267677e-02, -6.128604e-02, -1.654158e+00, +2.949942e-02, +3.142489e-01, +2.576984e+00, -2.384940e+00, -3.723324e-01, -2.533360e-01, -3.468462e+00, +1.444788e-02, +1.951681e+00, -8.115349e-01, +3.823899e+00, +1.365189e-01, +7.568180e-01, +1.047461e-01, +1.707155e+00, -4.719472e-01, +1.382578e+00, +1.715450e-01, -1.010905e+00, +4.643988e-02, -2.763080e-01, +3.663854e+00, -1.295061e-01, +2.961040e+00, +4.218003e-01, -1.997757e+00, -4.724865e+00, +3.823787e+00, +3.013666e-01, -1.618812e-01, +2.148789e+00, +1.484211e-01};
  parameter real inv_b1[0:23] = '{-9.823757e-02, -1.341862e+00, +2.596031e+00, -6.341727e-02, +3.815279e+00, -5.837768e-03, +1.145582e-01, -1.251424e-01, -4.720398e+00, +7.114959e-04, -3.816007e-02, -3.152223e-02, -2.775475e+00, -1.133235e+00, -1.659327e-04, -1.355994e+00, -5.803596e-02, -1.064213e-01, -2.922846e+00, -1.979288e+00, -7.236417e-02, +4.164723e-04, +1.605033e+00, -2.073071e-02};
  parameter real inv_W2[0:23] = '{-2.468454e-05, +2.442710e-05, +5.448001e-05, +5.235115e-06, -5.820481e-05, +2.610857e-06, -1.620109e-05, +4.370169e-06, -5.973726e-05, +3.690673e-06, -1.883196e-05, +1.571684e-06, +4.838729e-05, -4.099570e-05, -8.750842e-07, -4.029649e-05, -3.702501e-06, +3.107186e-05, +6.119389e-05, -5.052369e-05, -4.701940e-06, +2.150612e-06, +4.001679e-05, +1.153431e-06};
  parameter real inv_b2 = +1.918903e-06;

  real z_drive[0:47], h_drive[0:47], y_drive;
  real z_inv  [0:47], h_inv  [0:47], y_inv;
  real i_drive, i_inv;

  analog begin
    // NN forward pass: drive currents (pull-up + pull-down combined)
    z_drive[0] = drive_W1[0] * V(X, VSS) + drive_W1[48] * V(A, VSS) + drive_W1[96] * V(B, VSS) + drive_b1[0];
    if (z_drive[0] > 0.0) h_drive[0] = z_drive[0]; else h_drive[0] = 0.01 * z_drive[0];
    z_drive[1] = drive_W1[1] * V(X, VSS) + drive_W1[49] * V(A, VSS) + drive_W1[97] * V(B, VSS) + drive_b1[1];
    if (z_drive[1] > 0.0) h_drive[1] = z_drive[1]; else h_drive[1] = 0.01 * z_drive[1];
    z_drive[2] = drive_W1[2] * V(X, VSS) + drive_W1[50] * V(A, VSS) + drive_W1[98] * V(B, VSS) + drive_b1[2];
    if (z_drive[2] > 0.0) h_drive[2] = z_drive[2]; else h_drive[2] = 0.01 * z_drive[2];
    z_drive[3] = drive_W1[3] * V(X, VSS) + drive_W1[51] * V(A, VSS) + drive_W1[99] * V(B, VSS) + drive_b1[3];
    if (z_drive[3] > 0.0) h_drive[3] = z_drive[3]; else h_drive[3] = 0.01 * z_drive[3];
    z_drive[4] = drive_W1[4] * V(X, VSS) + drive_W1[52] * V(A, VSS) + drive_W1[100] * V(B, VSS) + drive_b1[4];
    if (z_drive[4] > 0.0) h_drive[4] = z_drive[4]; else h_drive[4] = 0.01 * z_drive[4];
    z_drive[5] = drive_W1[5] * V(X, VSS) + drive_W1[53] * V(A, VSS) + drive_W1[101] * V(B, VSS) + drive_b1[5];
    if (z_drive[5] > 0.0) h_drive[5] = z_drive[5]; else h_drive[5] = 0.01 * z_drive[5];
    z_drive[6] = drive_W1[6] * V(X, VSS) + drive_W1[54] * V(A, VSS) + drive_W1[102] * V(B, VSS) + drive_b1[6];
    if (z_drive[6] > 0.0) h_drive[6] = z_drive[6]; else h_drive[6] = 0.01 * z_drive[6];
    z_drive[7] = drive_W1[7] * V(X, VSS) + drive_W1[55] * V(A, VSS) + drive_W1[103] * V(B, VSS) + drive_b1[7];
    if (z_drive[7] > 0.0) h_drive[7] = z_drive[7]; else h_drive[7] = 0.01 * z_drive[7];
    z_drive[8] = drive_W1[8] * V(X, VSS) + drive_W1[56] * V(A, VSS) + drive_W1[104] * V(B, VSS) + drive_b1[8];
    if (z_drive[8] > 0.0) h_drive[8] = z_drive[8]; else h_drive[8] = 0.01 * z_drive[8];
    z_drive[9] = drive_W1[9] * V(X, VSS) + drive_W1[57] * V(A, VSS) + drive_W1[105] * V(B, VSS) + drive_b1[9];
    if (z_drive[9] > 0.0) h_drive[9] = z_drive[9]; else h_drive[9] = 0.01 * z_drive[9];
    z_drive[10] = drive_W1[10] * V(X, VSS) + drive_W1[58] * V(A, VSS) + drive_W1[106] * V(B, VSS) + drive_b1[10];
    if (z_drive[10] > 0.0) h_drive[10] = z_drive[10]; else h_drive[10] = 0.01 * z_drive[10];
    z_drive[11] = drive_W1[11] * V(X, VSS) + drive_W1[59] * V(A, VSS) + drive_W1[107] * V(B, VSS) + drive_b1[11];
    if (z_drive[11] > 0.0) h_drive[11] = z_drive[11]; else h_drive[11] = 0.01 * z_drive[11];
    z_drive[12] = drive_W1[12] * V(X, VSS) + drive_W1[60] * V(A, VSS) + drive_W1[108] * V(B, VSS) + drive_b1[12];
    if (z_drive[12] > 0.0) h_drive[12] = z_drive[12]; else h_drive[12] = 0.01 * z_drive[12];
    z_drive[13] = drive_W1[13] * V(X, VSS) + drive_W1[61] * V(A, VSS) + drive_W1[109] * V(B, VSS) + drive_b1[13];
    if (z_drive[13] > 0.0) h_drive[13] = z_drive[13]; else h_drive[13] = 0.01 * z_drive[13];
    z_drive[14] = drive_W1[14] * V(X, VSS) + drive_W1[62] * V(A, VSS) + drive_W1[110] * V(B, VSS) + drive_b1[14];
    if (z_drive[14] > 0.0) h_drive[14] = z_drive[14]; else h_drive[14] = 0.01 * z_drive[14];
    z_drive[15] = drive_W1[15] * V(X, VSS) + drive_W1[63] * V(A, VSS) + drive_W1[111] * V(B, VSS) + drive_b1[15];
    if (z_drive[15] > 0.0) h_drive[15] = z_drive[15]; else h_drive[15] = 0.01 * z_drive[15];
    z_drive[16] = drive_W1[16] * V(X, VSS) + drive_W1[64] * V(A, VSS) + drive_W1[112] * V(B, VSS) + drive_b1[16];
    if (z_drive[16] > 0.0) h_drive[16] = z_drive[16]; else h_drive[16] = 0.01 * z_drive[16];
    z_drive[17] = drive_W1[17] * V(X, VSS) + drive_W1[65] * V(A, VSS) + drive_W1[113] * V(B, VSS) + drive_b1[17];
    if (z_drive[17] > 0.0) h_drive[17] = z_drive[17]; else h_drive[17] = 0.01 * z_drive[17];
    z_drive[18] = drive_W1[18] * V(X, VSS) + drive_W1[66] * V(A, VSS) + drive_W1[114] * V(B, VSS) + drive_b1[18];
    if (z_drive[18] > 0.0) h_drive[18] = z_drive[18]; else h_drive[18] = 0.01 * z_drive[18];
    z_drive[19] = drive_W1[19] * V(X, VSS) + drive_W1[67] * V(A, VSS) + drive_W1[115] * V(B, VSS) + drive_b1[19];
    if (z_drive[19] > 0.0) h_drive[19] = z_drive[19]; else h_drive[19] = 0.01 * z_drive[19];
    z_drive[20] = drive_W1[20] * V(X, VSS) + drive_W1[68] * V(A, VSS) + drive_W1[116] * V(B, VSS) + drive_b1[20];
    if (z_drive[20] > 0.0) h_drive[20] = z_drive[20]; else h_drive[20] = 0.01 * z_drive[20];
    z_drive[21] = drive_W1[21] * V(X, VSS) + drive_W1[69] * V(A, VSS) + drive_W1[117] * V(B, VSS) + drive_b1[21];
    if (z_drive[21] > 0.0) h_drive[21] = z_drive[21]; else h_drive[21] = 0.01 * z_drive[21];
    z_drive[22] = drive_W1[22] * V(X, VSS) + drive_W1[70] * V(A, VSS) + drive_W1[118] * V(B, VSS) + drive_b1[22];
    if (z_drive[22] > 0.0) h_drive[22] = z_drive[22]; else h_drive[22] = 0.01 * z_drive[22];
    z_drive[23] = drive_W1[23] * V(X, VSS) + drive_W1[71] * V(A, VSS) + drive_W1[119] * V(B, VSS) + drive_b1[23];
    if (z_drive[23] > 0.0) h_drive[23] = z_drive[23]; else h_drive[23] = 0.01 * z_drive[23];
    z_drive[24] = drive_W1[24] * V(X, VSS) + drive_W1[72] * V(A, VSS) + drive_W1[120] * V(B, VSS) + drive_b1[24];
    if (z_drive[24] > 0.0) h_drive[24] = z_drive[24]; else h_drive[24] = 0.01 * z_drive[24];
    z_drive[25] = drive_W1[25] * V(X, VSS) + drive_W1[73] * V(A, VSS) + drive_W1[121] * V(B, VSS) + drive_b1[25];
    if (z_drive[25] > 0.0) h_drive[25] = z_drive[25]; else h_drive[25] = 0.01 * z_drive[25];
    z_drive[26] = drive_W1[26] * V(X, VSS) + drive_W1[74] * V(A, VSS) + drive_W1[122] * V(B, VSS) + drive_b1[26];
    if (z_drive[26] > 0.0) h_drive[26] = z_drive[26]; else h_drive[26] = 0.01 * z_drive[26];
    z_drive[27] = drive_W1[27] * V(X, VSS) + drive_W1[75] * V(A, VSS) + drive_W1[123] * V(B, VSS) + drive_b1[27];
    if (z_drive[27] > 0.0) h_drive[27] = z_drive[27]; else h_drive[27] = 0.01 * z_drive[27];
    z_drive[28] = drive_W1[28] * V(X, VSS) + drive_W1[76] * V(A, VSS) + drive_W1[124] * V(B, VSS) + drive_b1[28];
    if (z_drive[28] > 0.0) h_drive[28] = z_drive[28]; else h_drive[28] = 0.01 * z_drive[28];
    z_drive[29] = drive_W1[29] * V(X, VSS) + drive_W1[77] * V(A, VSS) + drive_W1[125] * V(B, VSS) + drive_b1[29];
    if (z_drive[29] > 0.0) h_drive[29] = z_drive[29]; else h_drive[29] = 0.01 * z_drive[29];
    z_drive[30] = drive_W1[30] * V(X, VSS) + drive_W1[78] * V(A, VSS) + drive_W1[126] * V(B, VSS) + drive_b1[30];
    if (z_drive[30] > 0.0) h_drive[30] = z_drive[30]; else h_drive[30] = 0.01 * z_drive[30];
    z_drive[31] = drive_W1[31] * V(X, VSS) + drive_W1[79] * V(A, VSS) + drive_W1[127] * V(B, VSS) + drive_b1[31];
    if (z_drive[31] > 0.0) h_drive[31] = z_drive[31]; else h_drive[31] = 0.01 * z_drive[31];
    z_drive[32] = drive_W1[32] * V(X, VSS) + drive_W1[80] * V(A, VSS) + drive_W1[128] * V(B, VSS) + drive_b1[32];
    if (z_drive[32] > 0.0) h_drive[32] = z_drive[32]; else h_drive[32] = 0.01 * z_drive[32];
    z_drive[33] = drive_W1[33] * V(X, VSS) + drive_W1[81] * V(A, VSS) + drive_W1[129] * V(B, VSS) + drive_b1[33];
    if (z_drive[33] > 0.0) h_drive[33] = z_drive[33]; else h_drive[33] = 0.01 * z_drive[33];
    z_drive[34] = drive_W1[34] * V(X, VSS) + drive_W1[82] * V(A, VSS) + drive_W1[130] * V(B, VSS) + drive_b1[34];
    if (z_drive[34] > 0.0) h_drive[34] = z_drive[34]; else h_drive[34] = 0.01 * z_drive[34];
    z_drive[35] = drive_W1[35] * V(X, VSS) + drive_W1[83] * V(A, VSS) + drive_W1[131] * V(B, VSS) + drive_b1[35];
    if (z_drive[35] > 0.0) h_drive[35] = z_drive[35]; else h_drive[35] = 0.01 * z_drive[35];
    z_drive[36] = drive_W1[36] * V(X, VSS) + drive_W1[84] * V(A, VSS) + drive_W1[132] * V(B, VSS) + drive_b1[36];
    if (z_drive[36] > 0.0) h_drive[36] = z_drive[36]; else h_drive[36] = 0.01 * z_drive[36];
    z_drive[37] = drive_W1[37] * V(X, VSS) + drive_W1[85] * V(A, VSS) + drive_W1[133] * V(B, VSS) + drive_b1[37];
    if (z_drive[37] > 0.0) h_drive[37] = z_drive[37]; else h_drive[37] = 0.01 * z_drive[37];
    z_drive[38] = drive_W1[38] * V(X, VSS) + drive_W1[86] * V(A, VSS) + drive_W1[134] * V(B, VSS) + drive_b1[38];
    if (z_drive[38] > 0.0) h_drive[38] = z_drive[38]; else h_drive[38] = 0.01 * z_drive[38];
    z_drive[39] = drive_W1[39] * V(X, VSS) + drive_W1[87] * V(A, VSS) + drive_W1[135] * V(B, VSS) + drive_b1[39];
    if (z_drive[39] > 0.0) h_drive[39] = z_drive[39]; else h_drive[39] = 0.01 * z_drive[39];
    z_drive[40] = drive_W1[40] * V(X, VSS) + drive_W1[88] * V(A, VSS) + drive_W1[136] * V(B, VSS) + drive_b1[40];
    if (z_drive[40] > 0.0) h_drive[40] = z_drive[40]; else h_drive[40] = 0.01 * z_drive[40];
    z_drive[41] = drive_W1[41] * V(X, VSS) + drive_W1[89] * V(A, VSS) + drive_W1[137] * V(B, VSS) + drive_b1[41];
    if (z_drive[41] > 0.0) h_drive[41] = z_drive[41]; else h_drive[41] = 0.01 * z_drive[41];
    z_drive[42] = drive_W1[42] * V(X, VSS) + drive_W1[90] * V(A, VSS) + drive_W1[138] * V(B, VSS) + drive_b1[42];
    if (z_drive[42] > 0.0) h_drive[42] = z_drive[42]; else h_drive[42] = 0.01 * z_drive[42];
    z_drive[43] = drive_W1[43] * V(X, VSS) + drive_W1[91] * V(A, VSS) + drive_W1[139] * V(B, VSS) + drive_b1[43];
    if (z_drive[43] > 0.0) h_drive[43] = z_drive[43]; else h_drive[43] = 0.01 * z_drive[43];
    z_drive[44] = drive_W1[44] * V(X, VSS) + drive_W1[92] * V(A, VSS) + drive_W1[140] * V(B, VSS) + drive_b1[44];
    if (z_drive[44] > 0.0) h_drive[44] = z_drive[44]; else h_drive[44] = 0.01 * z_drive[44];
    z_drive[45] = drive_W1[45] * V(X, VSS) + drive_W1[93] * V(A, VSS) + drive_W1[141] * V(B, VSS) + drive_b1[45];
    if (z_drive[45] > 0.0) h_drive[45] = z_drive[45]; else h_drive[45] = 0.01 * z_drive[45];
    z_drive[46] = drive_W1[46] * V(X, VSS) + drive_W1[94] * V(A, VSS) + drive_W1[142] * V(B, VSS) + drive_b1[46];
    if (z_drive[46] > 0.0) h_drive[46] = z_drive[46]; else h_drive[46] = 0.01 * z_drive[46];
    z_drive[47] = drive_W1[47] * V(X, VSS) + drive_W1[95] * V(A, VSS) + drive_W1[143] * V(B, VSS) + drive_b1[47];
    if (z_drive[47] > 0.0) h_drive[47] = z_drive[47]; else h_drive[47] = 0.01 * z_drive[47];
    y_drive = drive_W2[0] * h_drive[0] + drive_W2[1] * h_drive[1] + drive_W2[2] * h_drive[2] + drive_W2[3] * h_drive[3] + drive_W2[4] * h_drive[4] + drive_W2[5] * h_drive[5] + drive_W2[6] * h_drive[6] + drive_W2[7] * h_drive[7] + drive_W2[8] * h_drive[8] + drive_W2[9] * h_drive[9] + drive_W2[10] * h_drive[10] + drive_W2[11] * h_drive[11] + drive_W2[12] * h_drive[12] + drive_W2[13] * h_drive[13] + drive_W2[14] * h_drive[14] + drive_W2[15] * h_drive[15] + drive_W2[16] * h_drive[16] + drive_W2[17] * h_drive[17] + drive_W2[18] * h_drive[18] + drive_W2[19] * h_drive[19] + drive_W2[20] * h_drive[20] + drive_W2[21] * h_drive[21] + drive_W2[22] * h_drive[22] + drive_W2[23] * h_drive[23] + drive_W2[24] * h_drive[24] + drive_W2[25] * h_drive[25] + drive_W2[26] * h_drive[26] + drive_W2[27] * h_drive[27] + drive_W2[28] * h_drive[28] + drive_W2[29] * h_drive[29] + drive_W2[30] * h_drive[30] + drive_W2[31] * h_drive[31] + drive_W2[32] * h_drive[32] + drive_W2[33] * h_drive[33] + drive_W2[34] * h_drive[34] + drive_W2[35] * h_drive[35] + drive_W2[36] * h_drive[36] + drive_W2[37] * h_drive[37] + drive_W2[38] * h_drive[38] + drive_W2[39] * h_drive[39] + drive_W2[40] * h_drive[40] + drive_W2[41] * h_drive[41] + drive_W2[42] * h_drive[42] + drive_W2[43] * h_drive[43] + drive_W2[44] * h_drive[44] + drive_W2[45] * h_drive[45] + drive_W2[46] * h_drive[46] + drive_W2[47] * h_drive[47] + drive_b2;
    i_drive = y_drive;

    // NN forward pass: inverter current
    z_inv[0] = inv_W1[0] * V(X, VSS) + inv_W1[48] * V(Y, VSS) + inv_b1[0];
    if (z_inv[0] > 0.0) h_inv[0] = z_inv[0]; else h_inv[0] = 0.01 * z_inv[0];
    z_inv[1] = inv_W1[1] * V(X, VSS) + inv_W1[49] * V(Y, VSS) + inv_b1[1];
    if (z_inv[1] > 0.0) h_inv[1] = z_inv[1]; else h_inv[1] = 0.01 * z_inv[1];
    z_inv[2] = inv_W1[2] * V(X, VSS) + inv_W1[50] * V(Y, VSS) + inv_b1[2];
    if (z_inv[2] > 0.0) h_inv[2] = z_inv[2]; else h_inv[2] = 0.01 * z_inv[2];
    z_inv[3] = inv_W1[3] * V(X, VSS) + inv_W1[51] * V(Y, VSS) + inv_b1[3];
    if (z_inv[3] > 0.0) h_inv[3] = z_inv[3]; else h_inv[3] = 0.01 * z_inv[3];
    z_inv[4] = inv_W1[4] * V(X, VSS) + inv_W1[52] * V(Y, VSS) + inv_b1[4];
    if (z_inv[4] > 0.0) h_inv[4] = z_inv[4]; else h_inv[4] = 0.01 * z_inv[4];
    z_inv[5] = inv_W1[5] * V(X, VSS) + inv_W1[53] * V(Y, VSS) + inv_b1[5];
    if (z_inv[5] > 0.0) h_inv[5] = z_inv[5]; else h_inv[5] = 0.01 * z_inv[5];
    z_inv[6] = inv_W1[6] * V(X, VSS) + inv_W1[54] * V(Y, VSS) + inv_b1[6];
    if (z_inv[6] > 0.0) h_inv[6] = z_inv[6]; else h_inv[6] = 0.01 * z_inv[6];
    z_inv[7] = inv_W1[7] * V(X, VSS) + inv_W1[55] * V(Y, VSS) + inv_b1[7];
    if (z_inv[7] > 0.0) h_inv[7] = z_inv[7]; else h_inv[7] = 0.01 * z_inv[7];
    z_inv[8] = inv_W1[8] * V(X, VSS) + inv_W1[56] * V(Y, VSS) + inv_b1[8];
    if (z_inv[8] > 0.0) h_inv[8] = z_inv[8]; else h_inv[8] = 0.01 * z_inv[8];
    z_inv[9] = inv_W1[9] * V(X, VSS) + inv_W1[57] * V(Y, VSS) + inv_b1[9];
    if (z_inv[9] > 0.0) h_inv[9] = z_inv[9]; else h_inv[9] = 0.01 * z_inv[9];
    z_inv[10] = inv_W1[10] * V(X, VSS) + inv_W1[58] * V(Y, VSS) + inv_b1[10];
    if (z_inv[10] > 0.0) h_inv[10] = z_inv[10]; else h_inv[10] = 0.01 * z_inv[10];
    z_inv[11] = inv_W1[11] * V(X, VSS) + inv_W1[59] * V(Y, VSS) + inv_b1[11];
    if (z_inv[11] > 0.0) h_inv[11] = z_inv[11]; else h_inv[11] = 0.01 * z_inv[11];
    z_inv[12] = inv_W1[12] * V(X, VSS) + inv_W1[60] * V(Y, VSS) + inv_b1[12];
    if (z_inv[12] > 0.0) h_inv[12] = z_inv[12]; else h_inv[12] = 0.01 * z_inv[12];
    z_inv[13] = inv_W1[13] * V(X, VSS) + inv_W1[61] * V(Y, VSS) + inv_b1[13];
    if (z_inv[13] > 0.0) h_inv[13] = z_inv[13]; else h_inv[13] = 0.01 * z_inv[13];
    z_inv[14] = inv_W1[14] * V(X, VSS) + inv_W1[62] * V(Y, VSS) + inv_b1[14];
    if (z_inv[14] > 0.0) h_inv[14] = z_inv[14]; else h_inv[14] = 0.01 * z_inv[14];
    z_inv[15] = inv_W1[15] * V(X, VSS) + inv_W1[63] * V(Y, VSS) + inv_b1[15];
    if (z_inv[15] > 0.0) h_inv[15] = z_inv[15]; else h_inv[15] = 0.01 * z_inv[15];
    z_inv[16] = inv_W1[16] * V(X, VSS) + inv_W1[64] * V(Y, VSS) + inv_b1[16];
    if (z_inv[16] > 0.0) h_inv[16] = z_inv[16]; else h_inv[16] = 0.01 * z_inv[16];
    z_inv[17] = inv_W1[17] * V(X, VSS) + inv_W1[65] * V(Y, VSS) + inv_b1[17];
    if (z_inv[17] > 0.0) h_inv[17] = z_inv[17]; else h_inv[17] = 0.01 * z_inv[17];
    z_inv[18] = inv_W1[18] * V(X, VSS) + inv_W1[66] * V(Y, VSS) + inv_b1[18];
    if (z_inv[18] > 0.0) h_inv[18] = z_inv[18]; else h_inv[18] = 0.01 * z_inv[18];
    z_inv[19] = inv_W1[19] * V(X, VSS) + inv_W1[67] * V(Y, VSS) + inv_b1[19];
    if (z_inv[19] > 0.0) h_inv[19] = z_inv[19]; else h_inv[19] = 0.01 * z_inv[19];
    z_inv[20] = inv_W1[20] * V(X, VSS) + inv_W1[68] * V(Y, VSS) + inv_b1[20];
    if (z_inv[20] > 0.0) h_inv[20] = z_inv[20]; else h_inv[20] = 0.01 * z_inv[20];
    z_inv[21] = inv_W1[21] * V(X, VSS) + inv_W1[69] * V(Y, VSS) + inv_b1[21];
    if (z_inv[21] > 0.0) h_inv[21] = z_inv[21]; else h_inv[21] = 0.01 * z_inv[21];
    z_inv[22] = inv_W1[22] * V(X, VSS) + inv_W1[70] * V(Y, VSS) + inv_b1[22];
    if (z_inv[22] > 0.0) h_inv[22] = z_inv[22]; else h_inv[22] = 0.01 * z_inv[22];
    z_inv[23] = inv_W1[23] * V(X, VSS) + inv_W1[71] * V(Y, VSS) + inv_b1[23];
    if (z_inv[23] > 0.0) h_inv[23] = z_inv[23]; else h_inv[23] = 0.01 * z_inv[23];
    z_inv[24] = inv_W1[24] * V(X, VSS) + inv_W1[72] * V(Y, VSS) + inv_b1[24];
    if (z_inv[24] > 0.0) h_inv[24] = z_inv[24]; else h_inv[24] = 0.01 * z_inv[24];
    z_inv[25] = inv_W1[25] * V(X, VSS) + inv_W1[73] * V(Y, VSS) + inv_b1[25];
    if (z_inv[25] > 0.0) h_inv[25] = z_inv[25]; else h_inv[25] = 0.01 * z_inv[25];
    z_inv[26] = inv_W1[26] * V(X, VSS) + inv_W1[74] * V(Y, VSS) + inv_b1[26];
    if (z_inv[26] > 0.0) h_inv[26] = z_inv[26]; else h_inv[26] = 0.01 * z_inv[26];
    z_inv[27] = inv_W1[27] * V(X, VSS) + inv_W1[75] * V(Y, VSS) + inv_b1[27];
    if (z_inv[27] > 0.0) h_inv[27] = z_inv[27]; else h_inv[27] = 0.01 * z_inv[27];
    z_inv[28] = inv_W1[28] * V(X, VSS) + inv_W1[76] * V(Y, VSS) + inv_b1[28];
    if (z_inv[28] > 0.0) h_inv[28] = z_inv[28]; else h_inv[28] = 0.01 * z_inv[28];
    z_inv[29] = inv_W1[29] * V(X, VSS) + inv_W1[77] * V(Y, VSS) + inv_b1[29];
    if (z_inv[29] > 0.0) h_inv[29] = z_inv[29]; else h_inv[29] = 0.01 * z_inv[29];
    z_inv[30] = inv_W1[30] * V(X, VSS) + inv_W1[78] * V(Y, VSS) + inv_b1[30];
    if (z_inv[30] > 0.0) h_inv[30] = z_inv[30]; else h_inv[30] = 0.01 * z_inv[30];
    z_inv[31] = inv_W1[31] * V(X, VSS) + inv_W1[79] * V(Y, VSS) + inv_b1[31];
    if (z_inv[31] > 0.0) h_inv[31] = z_inv[31]; else h_inv[31] = 0.01 * z_inv[31];
    z_inv[32] = inv_W1[32] * V(X, VSS) + inv_W1[80] * V(Y, VSS) + inv_b1[32];
    if (z_inv[32] > 0.0) h_inv[32] = z_inv[32]; else h_inv[32] = 0.01 * z_inv[32];
    z_inv[33] = inv_W1[33] * V(X, VSS) + inv_W1[81] * V(Y, VSS) + inv_b1[33];
    if (z_inv[33] > 0.0) h_inv[33] = z_inv[33]; else h_inv[33] = 0.01 * z_inv[33];
    z_inv[34] = inv_W1[34] * V(X, VSS) + inv_W1[82] * V(Y, VSS) + inv_b1[34];
    if (z_inv[34] > 0.0) h_inv[34] = z_inv[34]; else h_inv[34] = 0.01 * z_inv[34];
    z_inv[35] = inv_W1[35] * V(X, VSS) + inv_W1[83] * V(Y, VSS) + inv_b1[35];
    if (z_inv[35] > 0.0) h_inv[35] = z_inv[35]; else h_inv[35] = 0.01 * z_inv[35];
    z_inv[36] = inv_W1[36] * V(X, VSS) + inv_W1[84] * V(Y, VSS) + inv_b1[36];
    if (z_inv[36] > 0.0) h_inv[36] = z_inv[36]; else h_inv[36] = 0.01 * z_inv[36];
    z_inv[37] = inv_W1[37] * V(X, VSS) + inv_W1[85] * V(Y, VSS) + inv_b1[37];
    if (z_inv[37] > 0.0) h_inv[37] = z_inv[37]; else h_inv[37] = 0.01 * z_inv[37];
    z_inv[38] = inv_W1[38] * V(X, VSS) + inv_W1[86] * V(Y, VSS) + inv_b1[38];
    if (z_inv[38] > 0.0) h_inv[38] = z_inv[38]; else h_inv[38] = 0.01 * z_inv[38];
    z_inv[39] = inv_W1[39] * V(X, VSS) + inv_W1[87] * V(Y, VSS) + inv_b1[39];
    if (z_inv[39] > 0.0) h_inv[39] = z_inv[39]; else h_inv[39] = 0.01 * z_inv[39];
    z_inv[40] = inv_W1[40] * V(X, VSS) + inv_W1[88] * V(Y, VSS) + inv_b1[40];
    if (z_inv[40] > 0.0) h_inv[40] = z_inv[40]; else h_inv[40] = 0.01 * z_inv[40];
    z_inv[41] = inv_W1[41] * V(X, VSS) + inv_W1[89] * V(Y, VSS) + inv_b1[41];
    if (z_inv[41] > 0.0) h_inv[41] = z_inv[41]; else h_inv[41] = 0.01 * z_inv[41];
    z_inv[42] = inv_W1[42] * V(X, VSS) + inv_W1[90] * V(Y, VSS) + inv_b1[42];
    if (z_inv[42] > 0.0) h_inv[42] = z_inv[42]; else h_inv[42] = 0.01 * z_inv[42];
    z_inv[43] = inv_W1[43] * V(X, VSS) + inv_W1[91] * V(Y, VSS) + inv_b1[43];
    if (z_inv[43] > 0.0) h_inv[43] = z_inv[43]; else h_inv[43] = 0.01 * z_inv[43];
    z_inv[44] = inv_W1[44] * V(X, VSS) + inv_W1[92] * V(Y, VSS) + inv_b1[44];
    if (z_inv[44] > 0.0) h_inv[44] = z_inv[44]; else h_inv[44] = 0.01 * z_inv[44];
    z_inv[45] = inv_W1[45] * V(X, VSS) + inv_W1[93] * V(Y, VSS) + inv_b1[45];
    if (z_inv[45] > 0.0) h_inv[45] = z_inv[45]; else h_inv[45] = 0.01 * z_inv[45];
    z_inv[46] = inv_W1[46] * V(X, VSS) + inv_W1[94] * V(Y, VSS) + inv_b1[46];
    if (z_inv[46] > 0.0) h_inv[46] = z_inv[46]; else h_inv[46] = 0.01 * z_inv[46];
    z_inv[47] = inv_W1[47] * V(X, VSS) + inv_W1[95] * V(Y, VSS) + inv_b1[47];
    if (z_inv[47] > 0.0) h_inv[47] = z_inv[47]; else h_inv[47] = 0.01 * z_inv[47];
    y_inv = inv_W2[0] * h_inv[0] + inv_W2[1] * h_inv[1] + inv_W2[2] * h_inv[2] + inv_W2[3] * h_inv[3] + inv_W2[4] * h_inv[4] + inv_W2[5] * h_inv[5] + inv_W2[6] * h_inv[6] + inv_W2[7] * h_inv[7] + inv_W2[8] * h_inv[8] + inv_W2[9] * h_inv[9] + inv_W2[10] * h_inv[10] + inv_W2[11] * h_inv[11] + inv_W2[12] * h_inv[12] + inv_W2[13] * h_inv[13] + inv_W2[14] * h_inv[14] + inv_W2[15] * h_inv[15] + inv_W2[16] * h_inv[16] + inv_W2[17] * h_inv[17] + inv_W2[18] * h_inv[18] + inv_W2[19] * h_inv[19] + inv_W2[20] * h_inv[20] + inv_W2[21] * h_inv[21] + inv_W2[22] * h_inv[22] + inv_W2[23] * h_inv[23] + inv_W2[24] * h_inv[24] + inv_W2[25] * h_inv[25] + inv_W2[26] * h_inv[26] + inv_W2[27] * h_inv[27] + inv_W2[28] * h_inv[28] + inv_W2[29] * h_inv[29] + inv_W2[30] * h_inv[30] + inv_W2[31] * h_inv[31] + inv_W2[32] * h_inv[32] + inv_W2[33] * h_inv[33] + inv_W2[34] * h_inv[34] + inv_W2[35] * h_inv[35] + inv_W2[36] * h_inv[36] + inv_W2[37] * h_inv[37] + inv_W2[38] * h_inv[38] + inv_W2[39] * h_inv[39] + inv_W2[40] * h_inv[40] + inv_W2[41] * h_inv[41] + inv_W2[42] * h_inv[42] + inv_W2[43] * h_inv[43] + inv_W2[44] * h_inv[44] + inv_W2[45] * h_inv[45] + inv_W2[46] * h_inv[46] + inv_W2[47] * h_inv[47] + inv_b2;
    i_inv = y_inv;

    // KCL at X: drive + analytical keeper + cap
    I(X, VSS) <+ -(i_drive);
    I(X, VSS) <+ -(V(VDD, VSS) - V(Y, VSS) - V(X, VSS)) / R_KEEP;
    I(X, VSS) <+ C_X * ddt(V(X, VSS));

    // KCL at Y: inverter + cap
    I(Y, VSS) <+ -(i_inv);
    I(Y, VSS) <+ C_Y * ddt(V(Y, VSS));
  end
endmodule
