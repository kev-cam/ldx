// th22_nn_hybrid.va — NN currents + analytical keeper.
// Generated by extract_nn_hybrid.py. Mirrors th22_hybrid.va topology;
// two small MLPs replace the IV-table lookups.

`include "disciplines.vams"
`include "constants.vams"

module th22_nn_hybrid(A, B, Y, VDD, VSS);
  input  A, B, VDD, VSS;
  output Y;
  electrical A, B, Y, VDD, VSS;
  electrical X;

  parameter real R_KEEP = 8.0e4;
  parameter real C_X    = 6.4e-15;
  parameter real C_Y    = 5.0e-15;

  parameter real drive_W1[0:29] = '{-6.757553e-02, +5.771494e-01, -7.459418e-02, -1.910015e-01, -2.428427e-01, +4.137539e-01, -2.119856e-01, +2.273992e-01, -1.466404e-01, -1.637514e-01, +5.954984e-01, +5.510343e-01, +3.498088e-01, -7.722267e-01, -5.458179e-02, +7.693095e-01, -6.424746e-01, -4.512769e-01, -5.679804e-01, -3.901301e-01, -1.214220e+00, +5.823394e-01, -7.137135e-01, +3.569326e-01, -1.154496e-01, +7.440680e-01, -8.157561e-01, -7.791761e-01, -1.162216e-02, +1.609831e-01};
  parameter real drive_b1[0:9] = '{+9.934899e-03, +6.177596e-03, +1.387088e-02, +7.247484e-02, +5.626499e-01, +6.992260e-03, +6.000466e-01, +1.407551e+00, -1.973726e-03, +6.893641e-02};
  parameter real drive_W2[0:9] = '{-1.309437e-05, -9.818310e-06, -7.552886e-06, -8.171588e-06, +6.821628e-06, -1.109054e-05, +8.660420e-06, +1.634116e-05, -1.660220e-06, -1.591694e-06};
  parameter real drive_b2 = +1.172497e-05;

  parameter real inv_W1[0:19] = '{+1.907087e+00, +2.405658e+00, +7.217546e-01, -1.499515e-01, -8.035444e-02, -2.210635e+00, +9.255030e-01, -1.120000e-02, +1.855575e+00, -8.673892e-01, +6.325447e-01, +7.784196e-01, +3.323383e-01, -4.192127e-02, -1.164752e-01, +2.638306e+00, +4.765327e-01, -6.246720e-02, +6.134318e-01, +6.270299e-01};
  parameter real inv_b1[0:9] = '{-2.106788e+00, +2.222002e-02, +5.827101e-03, -6.491180e-03, -1.872283e-02, -1.715634e+00, +8.761013e-03, -1.164750e-02, +1.751248e-02, +2.657909e+00};
  parameter real inv_W2[0:9] = '{-2.869649e-05, -2.488375e-05, -6.761260e-06, -1.990936e-06, -5.756212e-06, -3.843658e-05, -9.892535e-06, -3.582228e-06, -1.953356e-05, +2.744317e-05};
  parameter real inv_b2 = +3.253490e-05;

  real z_drive[0:9], h_drive[0:9], y_drive;
  real z_inv  [0:9], h_inv  [0:9], y_inv;
  real i_drive, i_inv;

  analog begin
    // NN forward pass: drive currents (pull-up + pull-down combined)
    z_drive[0] = drive_W1[0] * V(X, VSS) + drive_W1[10] * V(A, VSS) + drive_W1[20] * V(B, VSS) + drive_b1[0];
    if (z_drive[0] > 0.0) h_drive[0] = z_drive[0]; else h_drive[0] = 0.01 * z_drive[0];
    z_drive[1] = drive_W1[1] * V(X, VSS) + drive_W1[11] * V(A, VSS) + drive_W1[21] * V(B, VSS) + drive_b1[1];
    if (z_drive[1] > 0.0) h_drive[1] = z_drive[1]; else h_drive[1] = 0.01 * z_drive[1];
    z_drive[2] = drive_W1[2] * V(X, VSS) + drive_W1[12] * V(A, VSS) + drive_W1[22] * V(B, VSS) + drive_b1[2];
    if (z_drive[2] > 0.0) h_drive[2] = z_drive[2]; else h_drive[2] = 0.01 * z_drive[2];
    z_drive[3] = drive_W1[3] * V(X, VSS) + drive_W1[13] * V(A, VSS) + drive_W1[23] * V(B, VSS) + drive_b1[3];
    if (z_drive[3] > 0.0) h_drive[3] = z_drive[3]; else h_drive[3] = 0.01 * z_drive[3];
    z_drive[4] = drive_W1[4] * V(X, VSS) + drive_W1[14] * V(A, VSS) + drive_W1[24] * V(B, VSS) + drive_b1[4];
    if (z_drive[4] > 0.0) h_drive[4] = z_drive[4]; else h_drive[4] = 0.01 * z_drive[4];
    z_drive[5] = drive_W1[5] * V(X, VSS) + drive_W1[15] * V(A, VSS) + drive_W1[25] * V(B, VSS) + drive_b1[5];
    if (z_drive[5] > 0.0) h_drive[5] = z_drive[5]; else h_drive[5] = 0.01 * z_drive[5];
    z_drive[6] = drive_W1[6] * V(X, VSS) + drive_W1[16] * V(A, VSS) + drive_W1[26] * V(B, VSS) + drive_b1[6];
    if (z_drive[6] > 0.0) h_drive[6] = z_drive[6]; else h_drive[6] = 0.01 * z_drive[6];
    z_drive[7] = drive_W1[7] * V(X, VSS) + drive_W1[17] * V(A, VSS) + drive_W1[27] * V(B, VSS) + drive_b1[7];
    if (z_drive[7] > 0.0) h_drive[7] = z_drive[7]; else h_drive[7] = 0.01 * z_drive[7];
    z_drive[8] = drive_W1[8] * V(X, VSS) + drive_W1[18] * V(A, VSS) + drive_W1[28] * V(B, VSS) + drive_b1[8];
    if (z_drive[8] > 0.0) h_drive[8] = z_drive[8]; else h_drive[8] = 0.01 * z_drive[8];
    z_drive[9] = drive_W1[9] * V(X, VSS) + drive_W1[19] * V(A, VSS) + drive_W1[29] * V(B, VSS) + drive_b1[9];
    if (z_drive[9] > 0.0) h_drive[9] = z_drive[9]; else h_drive[9] = 0.01 * z_drive[9];
    y_drive = drive_W2[0] * h_drive[0] + drive_W2[1] * h_drive[1] + drive_W2[2] * h_drive[2] + drive_W2[3] * h_drive[3] + drive_W2[4] * h_drive[4] + drive_W2[5] * h_drive[5] + drive_W2[6] * h_drive[6] + drive_W2[7] * h_drive[7] + drive_W2[8] * h_drive[8] + drive_W2[9] * h_drive[9] + drive_b2;
    i_drive = y_drive;

    // NN forward pass: inverter current
    z_inv[0] = inv_W1[0] * V(X, VSS) + inv_W1[10] * V(Y, VSS) + inv_b1[0];
    if (z_inv[0] > 0.0) h_inv[0] = z_inv[0]; else h_inv[0] = 0.01 * z_inv[0];
    z_inv[1] = inv_W1[1] * V(X, VSS) + inv_W1[11] * V(Y, VSS) + inv_b1[1];
    if (z_inv[1] > 0.0) h_inv[1] = z_inv[1]; else h_inv[1] = 0.01 * z_inv[1];
    z_inv[2] = inv_W1[2] * V(X, VSS) + inv_W1[12] * V(Y, VSS) + inv_b1[2];
    if (z_inv[2] > 0.0) h_inv[2] = z_inv[2]; else h_inv[2] = 0.01 * z_inv[2];
    z_inv[3] = inv_W1[3] * V(X, VSS) + inv_W1[13] * V(Y, VSS) + inv_b1[3];
    if (z_inv[3] > 0.0) h_inv[3] = z_inv[3]; else h_inv[3] = 0.01 * z_inv[3];
    z_inv[4] = inv_W1[4] * V(X, VSS) + inv_W1[14] * V(Y, VSS) + inv_b1[4];
    if (z_inv[4] > 0.0) h_inv[4] = z_inv[4]; else h_inv[4] = 0.01 * z_inv[4];
    z_inv[5] = inv_W1[5] * V(X, VSS) + inv_W1[15] * V(Y, VSS) + inv_b1[5];
    if (z_inv[5] > 0.0) h_inv[5] = z_inv[5]; else h_inv[5] = 0.01 * z_inv[5];
    z_inv[6] = inv_W1[6] * V(X, VSS) + inv_W1[16] * V(Y, VSS) + inv_b1[6];
    if (z_inv[6] > 0.0) h_inv[6] = z_inv[6]; else h_inv[6] = 0.01 * z_inv[6];
    z_inv[7] = inv_W1[7] * V(X, VSS) + inv_W1[17] * V(Y, VSS) + inv_b1[7];
    if (z_inv[7] > 0.0) h_inv[7] = z_inv[7]; else h_inv[7] = 0.01 * z_inv[7];
    z_inv[8] = inv_W1[8] * V(X, VSS) + inv_W1[18] * V(Y, VSS) + inv_b1[8];
    if (z_inv[8] > 0.0) h_inv[8] = z_inv[8]; else h_inv[8] = 0.01 * z_inv[8];
    z_inv[9] = inv_W1[9] * V(X, VSS) + inv_W1[19] * V(Y, VSS) + inv_b1[9];
    if (z_inv[9] > 0.0) h_inv[9] = z_inv[9]; else h_inv[9] = 0.01 * z_inv[9];
    y_inv = inv_W2[0] * h_inv[0] + inv_W2[1] * h_inv[1] + inv_W2[2] * h_inv[2] + inv_W2[3] * h_inv[3] + inv_W2[4] * h_inv[4] + inv_W2[5] * h_inv[5] + inv_W2[6] * h_inv[6] + inv_W2[7] * h_inv[7] + inv_W2[8] * h_inv[8] + inv_W2[9] * h_inv[9] + inv_b2;
    i_inv = y_inv;

    // KCL at X: drive + analytical keeper + cap
    I(X, VSS) <+ -(i_drive);
    I(X, VSS) <+ -(V(VDD, VSS) - V(Y, VSS) - V(X, VSS)) / R_KEEP;
    I(X, VSS) <+ C_X * ddt(V(X, VSS));

    // KCL at Y: inverter + cap
    I(Y, VSS) <+ -(i_inv);
    I(Y, VSS) <+ C_Y * ddt(V(Y, VSS));
  end
endmodule
